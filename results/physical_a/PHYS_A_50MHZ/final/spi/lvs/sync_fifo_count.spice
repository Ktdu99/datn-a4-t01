* NGSPICE file created from sync_fifo_count.ext - technology: sky130A

* Black-box entry subcircuit for sky130_fd_sc_hd__tapvpwrvgnd_1 abstract view
.subckt sky130_fd_sc_hd__tapvpwrvgnd_1 VGND VPWR
.ends

* Black-box entry subcircuit for sky130_fd_sc_hd__decap_4 abstract view
.subckt sky130_fd_sc_hd__decap_4 VGND VNB VPB VPWR
.ends

* Black-box entry subcircuit for sky130_ef_sc_hd__decap_12 abstract view
.subckt sky130_ef_sc_hd__decap_12 VPWR VGND VPB VNB
.ends

* Black-box entry subcircuit for sky130_fd_sc_hd__decap_6 abstract view
.subckt sky130_fd_sc_hd__decap_6 VGND VNB VPB VPWR
.ends

* Black-box entry subcircuit for sky130_fd_sc_hd__fill_1 abstract view
.subckt sky130_fd_sc_hd__fill_1 VGND VNB VPB VPWR
.ends

* Black-box entry subcircuit for sky130_fd_sc_hd__dfxtp_1 abstract view
.subckt sky130_fd_sc_hd__dfxtp_1 CLK D VGND VNB VPB VPWR Q
.ends

* Black-box entry subcircuit for sky130_fd_sc_hd__fill_2 abstract view
.subckt sky130_fd_sc_hd__fill_2 VGND VNB VPB VPWR
.ends

* Black-box entry subcircuit for sky130_fd_sc_hd__nor2_4 abstract view
.subckt sky130_fd_sc_hd__nor2_4 A B VGND VNB VPB VPWR Y
.ends

* Black-box entry subcircuit for sky130_fd_sc_hd__clkbuf_8 abstract view
.subckt sky130_fd_sc_hd__clkbuf_8 A VGND VNB VPB VPWR X
.ends

* Black-box entry subcircuit for sky130_fd_sc_hd__nand2_4 abstract view
.subckt sky130_fd_sc_hd__nand2_4 A B VGND VNB VPB VPWR Y
.ends

* Black-box entry subcircuit for sky130_fd_sc_hd__clkbuf_1 abstract view
.subckt sky130_fd_sc_hd__clkbuf_1 A VGND VNB VPB VPWR X
.ends

* Black-box entry subcircuit for sky130_fd_sc_hd__clkbuf_4 abstract view
.subckt sky130_fd_sc_hd__clkbuf_4 A VGND VNB VPB VPWR X
.ends

* Black-box entry subcircuit for sky130_fd_sc_hd__decap_3 abstract view
.subckt sky130_fd_sc_hd__decap_3 VGND VNB VPB VPWR
.ends

* Black-box entry subcircuit for sky130_fd_sc_hd__mux4_1 abstract view
.subckt sky130_fd_sc_hd__mux4_1 A0 A1 A2 A3 S0 S1 VGND VNB VPB VPWR X
.ends

* Black-box entry subcircuit for sky130_fd_sc_hd__mux2_1 abstract view
.subckt sky130_fd_sc_hd__mux2_1 A0 A1 S VGND VNB VPB VPWR X
.ends

* Black-box entry subcircuit for sky130_fd_sc_hd__dlygate4sd3_1 abstract view
.subckt sky130_fd_sc_hd__dlygate4sd3_1 A VGND VNB VPB VPWR X
.ends

* Black-box entry subcircuit for sky130_fd_sc_hd__decap_8 abstract view
.subckt sky130_fd_sc_hd__decap_8 VGND VNB VPB VPWR
.ends

* Black-box entry subcircuit for sky130_fd_sc_hd__buf_2 abstract view
.subckt sky130_fd_sc_hd__buf_2 A VGND VNB VPB VPWR X
.ends

* Black-box entry subcircuit for sky130_fd_sc_hd__and3b_4 abstract view
.subckt sky130_fd_sc_hd__and3b_4 A_N B C VGND VNB VPB VPWR X
.ends

* Black-box entry subcircuit for sky130_fd_sc_hd__and2_1 abstract view
.subckt sky130_fd_sc_hd__and2_1 A B VGND VNB VPB VPWR X
.ends

* Black-box entry subcircuit for sky130_fd_sc_hd__o221a_1 abstract view
.subckt sky130_fd_sc_hd__o221a_1 A1 A2 B1 B2 C1 VGND VNB VPB VPWR X
.ends

* Black-box entry subcircuit for sky130_fd_sc_hd__dlymetal6s2s_1 abstract view
.subckt sky130_fd_sc_hd__dlymetal6s2s_1 A VGND VNB VPB VPWR X
.ends

* Black-box entry subcircuit for sky130_fd_sc_hd__and4bb_4 abstract view
.subckt sky130_fd_sc_hd__and4bb_4 A_N B_N C D VGND VNB VPB VPWR X
.ends

* Black-box entry subcircuit for sky130_fd_sc_hd__a21o_1 abstract view
.subckt sky130_fd_sc_hd__a21o_1 A1 A2 B1 VGND VNB VPB VPWR X
.ends

* Black-box entry subcircuit for sky130_fd_sc_hd__buf_4 abstract view
.subckt sky130_fd_sc_hd__buf_4 A VGND VNB VPB VPWR X
.ends

* Black-box entry subcircuit for sky130_fd_sc_hd__a22o_1 abstract view
.subckt sky130_fd_sc_hd__a22o_1 A1 A2 B1 B2 VGND VNB VPB VPWR X
.ends

* Black-box entry subcircuit for sky130_fd_sc_hd__o311a_1 abstract view
.subckt sky130_fd_sc_hd__o311a_1 A1 A2 A3 B1 C1 VGND VNB VPB VPWR X
.ends

* Black-box entry subcircuit for sky130_fd_sc_hd__nor2_1 abstract view
.subckt sky130_fd_sc_hd__nor2_1 A B VGND VNB VPB VPWR Y
.ends

* Black-box entry subcircuit for sky130_fd_sc_hd__inv_2 abstract view
.subckt sky130_fd_sc_hd__inv_2 A VGND VNB VPB VPWR Y
.ends

* Black-box entry subcircuit for sky130_fd_sc_hd__a221o_1 abstract view
.subckt sky130_fd_sc_hd__a221o_1 A1 A2 B1 B2 C1 VGND VNB VPB VPWR X
.ends

* Black-box entry subcircuit for sky130_fd_sc_hd__xnor2_1 abstract view
.subckt sky130_fd_sc_hd__xnor2_1 A B VGND VNB VPB VPWR Y
.ends

* Black-box entry subcircuit for sky130_fd_sc_hd__or4_2 abstract view
.subckt sky130_fd_sc_hd__or4_2 A B C D VGND VNB VPB VPWR X
.ends

* Black-box entry subcircuit for sky130_fd_sc_hd__and2b_1 abstract view
.subckt sky130_fd_sc_hd__and2b_1 A_N B VGND VNB VPB VPWR X
.ends

* Black-box entry subcircuit for sky130_fd_sc_hd__o21a_2 abstract view
.subckt sky130_fd_sc_hd__o21a_2 A1 A2 B1 VGND VNB VPB VPWR X
.ends

* Black-box entry subcircuit for sky130_fd_sc_hd__xor2_1 abstract view
.subckt sky130_fd_sc_hd__xor2_1 A B VGND VNB VPB VPWR X
.ends

* Black-box entry subcircuit for sky130_fd_sc_hd__and3_1 abstract view
.subckt sky130_fd_sc_hd__and3_1 A B C VGND VNB VPB VPWR X
.ends

* Black-box entry subcircuit for sky130_fd_sc_hd__and3b_1 abstract view
.subckt sky130_fd_sc_hd__and3b_1 A_N B C VGND VNB VPB VPWR X
.ends

* Black-box entry subcircuit for sky130_fd_sc_hd__a21bo_2 abstract view
.subckt sky130_fd_sc_hd__a21bo_2 A1 A2 B1_N VGND VNB VPB VPWR X
.ends

* Black-box entry subcircuit for sky130_fd_sc_hd__or2_1 abstract view
.subckt sky130_fd_sc_hd__or2_1 A B VGND VNB VPB VPWR X
.ends

* Black-box entry subcircuit for sky130_fd_sc_hd__clkbuf_16 abstract view
.subckt sky130_fd_sc_hd__clkbuf_16 A VGND VNB VPB VPWR X
.ends

* Black-box entry subcircuit for sky130_fd_sc_hd__xor2_2 abstract view
.subckt sky130_fd_sc_hd__xor2_2 A B VGND VNB VPB VPWR X
.ends

* Black-box entry subcircuit for sky130_fd_sc_hd__dfxtp_2 abstract view
.subckt sky130_fd_sc_hd__dfxtp_2 CLK D VGND VNB VPB VPWR Q
.ends

* Black-box entry subcircuit for sky130_fd_sc_hd__a22oi_1 abstract view
.subckt sky130_fd_sc_hd__a22oi_1 A1 A2 B1 B2 VGND VNB VPB VPWR Y
.ends

* Black-box entry subcircuit for sky130_fd_sc_hd__dfxtp_4 abstract view
.subckt sky130_fd_sc_hd__dfxtp_4 CLK D VGND VNB VPB VPWR Q
.ends

* Black-box entry subcircuit for sky130_fd_sc_hd__o21a_1 abstract view
.subckt sky130_fd_sc_hd__o21a_1 A1 A2 B1 VGND VNB VPB VPWR X
.ends

* Black-box entry subcircuit for sky130_fd_sc_hd__or3b_1 abstract view
.subckt sky130_fd_sc_hd__or3b_1 A B C_N VGND VNB VPB VPWR X
.ends

* Black-box entry subcircuit for sky130_fd_sc_hd__a21oi_1 abstract view
.subckt sky130_fd_sc_hd__a21oi_1 A1 A2 B1 VGND VNB VPB VPWR Y
.ends

* Black-box entry subcircuit for sky130_fd_sc_hd__and2b_2 abstract view
.subckt sky130_fd_sc_hd__and2b_2 A_N B VGND VNB VPB VPWR X
.ends

* Black-box entry subcircuit for sky130_fd_sc_hd__and4b_4 abstract view
.subckt sky130_fd_sc_hd__and4b_4 A_N B C D VGND VNB VPB VPWR X
.ends

* Black-box entry subcircuit for sky130_fd_sc_hd__or2b_1 abstract view
.subckt sky130_fd_sc_hd__or2b_1 A B_N VGND VNB VPB VPWR X
.ends

* Black-box entry subcircuit for sky130_fd_sc_hd__nor4_1 abstract view
.subckt sky130_fd_sc_hd__nor4_1 A B C D VGND VNB VPB VPWR Y
.ends

* Black-box entry subcircuit for sky130_fd_sc_hd__clkbuf_2 abstract view
.subckt sky130_fd_sc_hd__clkbuf_2 A VGND VNB VPB VPWR X
.ends

* Black-box entry subcircuit for sky130_fd_sc_hd__buf_1 abstract view
.subckt sky130_fd_sc_hd__buf_1 A VGND VNB VPB VPWR X
.ends

* Black-box entry subcircuit for sky130_fd_sc_hd__o2111a_1 abstract view
.subckt sky130_fd_sc_hd__o2111a_1 A1 A2 B1 C1 D1 VGND VNB VPB VPWR X
.ends

* Black-box entry subcircuit for sky130_fd_sc_hd__a31o_1 abstract view
.subckt sky130_fd_sc_hd__a31o_1 A1 A2 A3 B1 VGND VNB VPB VPWR X
.ends

* Black-box entry subcircuit for sky130_fd_sc_hd__o21ai_4 abstract view
.subckt sky130_fd_sc_hd__o21ai_4 A1 A2 B1 VGND VNB VPB VPWR Y
.ends

* Black-box entry subcircuit for sky130_fd_sc_hd__nand2_1 abstract view
.subckt sky130_fd_sc_hd__nand2_1 A B VGND VNB VPB VPWR Y
.ends

* Black-box entry subcircuit for sky130_fd_sc_hd__xnor2_2 abstract view
.subckt sky130_fd_sc_hd__xnor2_2 A B VGND VNB VPB VPWR Y
.ends

* Black-box entry subcircuit for sky130_fd_sc_hd__o21ai_1 abstract view
.subckt sky130_fd_sc_hd__o21ai_1 A1 A2 B1 VGND VNB VPB VPWR Y
.ends

* Black-box entry subcircuit for sky130_fd_sc_hd__nand2b_4 abstract view
.subckt sky130_fd_sc_hd__nand2b_4 A_N B VGND VNB VPB VPWR Y
.ends

* Black-box entry subcircuit for sky130_fd_sc_hd__and2_2 abstract view
.subckt sky130_fd_sc_hd__and2_2 A B VGND VNB VPB VPWR X
.ends

* Black-box entry subcircuit for sky130_fd_sc_hd__and3_2 abstract view
.subckt sky130_fd_sc_hd__and3_2 A B C VGND VNB VPB VPWR X
.ends

* Black-box entry subcircuit for sky130_fd_sc_hd__a21boi_4 abstract view
.subckt sky130_fd_sc_hd__a21boi_4 A1 A2 B1_N VGND VNB VPB VPWR Y
.ends

.subckt sync_fifo_count VGND VPWR clk empty full overflow rd_data[0] rd_data[1] rd_data[2]
+ rd_data[3] rd_data[4] rd_data[5] rd_data[6] rd_data[7] rd_en rst_n underflow wr_data[0]
+ wr_data[1] wr_data[2] wr_data[3] wr_data[4] wr_data[5] wr_data[6] wr_data[7] wr_en
XTAP_177 VGND VPWR sky130_fd_sc_hd__tapvpwrvgnd_1
XTAP_188 VGND VPWR sky130_fd_sc_hd__tapvpwrvgnd_1
XTAP_199 VGND VPWR sky130_fd_sc_hd__tapvpwrvgnd_1
XFILLER_0_27_93 VGND VGND VPWR VPWR sky130_fd_sc_hd__decap_4
XFILLER_0_32_269 VPWR VGND VPWR VGND sky130_ef_sc_hd__decap_12
XFILLER_0_7_81 VGND VGND VPWR VPWR sky130_fd_sc_hd__decap_6
XFILLER_0_48_15 VPWR VGND VPWR VGND sky130_ef_sc_hd__decap_12
XFILLER_0_13_73 VGND VGND VPWR VPWR sky130_fd_sc_hd__fill_1
X_0985_ clknet_4_2_0_clk _0089_ VGND VGND VPWR VPWR memory\[10\]\[0\] sky130_fd_sc_hd__dfxtp_1
XFILLER_0_14_247 VGND VGND VPWR VPWR sky130_fd_sc_hd__decap_4
XFILLER_0_1_185 VPWR VGND VPWR VGND sky130_ef_sc_hd__decap_12
XFILLER_0_49_166 VGND VGND VPWR VPWR sky130_fd_sc_hd__fill_2
XFILLER_0_18_29 VGND VGND VPWR VPWR sky130_fd_sc_hd__fill_2
XFILLER_0_50_27 VGND VGND VPWR VPWR sky130_fd_sc_hd__fill_1
X_0770_ _0210_ _0298_ VGND VGND VPWR VPWR _0367_ sky130_fd_sc_hd__nor2_4
Xclkbuf_4_12_0_clk clknet_0_clk VGND VGND VPWR VPWR clknet_4_12_0_clk sky130_fd_sc_hd__clkbuf_8
XFILLER_0_6_277 VPWR VGND VPWR VGND sky130_ef_sc_hd__decap_12
X_0968_ clknet_4_1_0_clk _0072_ VGND VGND VPWR VPWR memory\[14\]\[7\] sky130_fd_sc_hd__dfxtp_1
XFILLER_0_24_83 VGND VGND VPWR VPWR sky130_fd_sc_hd__fill_1
XFILLER_0_40_93 VPWR VGND VPWR VGND sky130_ef_sc_hd__decap_12
XFILLER_0_40_82 VGND VGND VPWR VPWR sky130_fd_sc_hd__fill_2
X_0899_ clknet_4_1_0_clk _0003_ VGND VGND VPWR VPWR memory\[15\]\[3\] sky130_fd_sc_hd__dfxtp_1
XFILLER_0_4_82 VGND VGND VPWR VPWR sky130_fd_sc_hd__fill_2
XFILLER_0_45_27 VPWR VGND VPWR VGND sky130_ef_sc_hd__decap_12
XFILLER_0_0_29 VPWR VGND VPWR VGND sky130_ef_sc_hd__decap_12
XFILLER_0_9_27 VPWR VGND VPWR VGND sky130_ef_sc_hd__decap_12
XFILLER_0_28_136 VGND VGND VPWR VPWR sky130_fd_sc_hd__fill_1
X_0822_ _0177_ _0199_ VGND VGND VPWR VPWR _0395_ sky130_fd_sc_hd__nand2_4
XFILLER_0_36_191 VGND VGND VPWR VPWR sky130_fd_sc_hd__decap_4
XFILLER_0_3_225 VPWR VGND VPWR VGND sky130_ef_sc_hd__decap_12
X_0684_ _0320_ VGND VGND VPWR VPWR _0065_ sky130_fd_sc_hd__clkbuf_1
X_0753_ _0357_ VGND VGND VPWR VPWR _0358_ sky130_fd_sc_hd__clkbuf_4
XFILLER_0_51_81 VGND VGND VPWR VPWR sky130_fd_sc_hd__decap_3
XFILLER_0_19_169 VPWR VGND VPWR VGND sky130_ef_sc_hd__decap_12
X_1021_ clknet_4_11_0_clk _0125_ VGND VGND VPWR VPWR memory\[8\]\[4\] sky130_fd_sc_hd__dfxtp_1
XFILLER_0_16_106 VGND VGND VPWR VPWR sky130_fd_sc_hd__fill_1
X_0805_ _0385_ VGND VGND VPWR VPWR _0386_ sky130_fd_sc_hd__clkbuf_4
X_0598_ memory\[0\]\[3\] memory\[1\]\[3\] memory\[2\]\[3\] memory\[3\]\[3\] _0231_
+ _0237_ VGND VGND VPWR VPWR _0256_ sky130_fd_sc_hd__mux4_1
X_0667_ _0311_ VGND VGND VPWR VPWR _0057_ sky130_fd_sc_hd__clkbuf_1
X_0736_ _0154_ net99 _0348_ VGND VGND VPWR VPWR _0349_ sky130_fd_sc_hd__mux2_1
XFILLER_0_34_3 VPWR VGND VPWR VGND sky130_ef_sc_hd__decap_12
XFILLER_0_22_109 VGND VGND VPWR VPWR sky130_fd_sc_hd__decap_6
Xhold41 memory\[7\]\[4\] VGND VGND VPWR VPWR net66 sky130_fd_sc_hd__dlygate4sd3_1
Xhold52 memory\[7\]\[6\] VGND VGND VPWR VPWR net77 sky130_fd_sc_hd__dlygate4sd3_1
Xhold74 memory\[10\]\[0\] VGND VGND VPWR VPWR net99 sky130_fd_sc_hd__dlygate4sd3_1
Xhold30 memory\[15\]\[0\] VGND VGND VPWR VPWR net55 sky130_fd_sc_hd__dlygate4sd3_1
Xhold63 memory\[5\]\[0\] VGND VGND VPWR VPWR net88 sky130_fd_sc_hd__dlygate4sd3_1
Xhold85 memory\[5\]\[1\] VGND VGND VPWR VPWR net110 sky130_fd_sc_hd__dlygate4sd3_1
Xhold96 memory\[0\]\[3\] VGND VGND VPWR VPWR net121 sky130_fd_sc_hd__dlygate4sd3_1
XFILLER_0_38_297 VGND VGND VPWR VPWR sky130_fd_sc_hd__decap_8
XTAP_348 VGND VPWR sky130_fd_sc_hd__tapvpwrvgnd_1
XTAP_337 VGND VPWR sky130_fd_sc_hd__tapvpwrvgnd_1
XTAP_326 VGND VPWR sky130_fd_sc_hd__tapvpwrvgnd_1
XTAP_315 VGND VPWR sky130_fd_sc_hd__tapvpwrvgnd_1
XTAP_304 VGND VPWR sky130_fd_sc_hd__tapvpwrvgnd_1
X_0452_ net3 VGND VGND VPWR VPWR _0154_ sky130_fd_sc_hd__buf_2
X_0521_ _0198_ VGND VGND VPWR VPWR _0024_ sky130_fd_sc_hd__clkbuf_1
XFILLER_0_21_142 VGND VGND VPWR VPWR sky130_fd_sc_hd__fill_1
XTAP_359 VGND VPWR sky130_fd_sc_hd__tapvpwrvgnd_1
XFILLER_0_16_62 VPWR VGND VPWR VGND sky130_ef_sc_hd__decap_12
X_1004_ clknet_4_7_0_clk _0108_ VGND VGND VPWR VPWR memory\[0\]\[3\] sky130_fd_sc_hd__dfxtp_1
XFILLER_0_44_289 VPWR VGND VPWR VGND sky130_ef_sc_hd__decap_12
XFILLER_0_12_153 VGND VGND VPWR VPWR sky130_fd_sc_hd__decap_6
X_0719_ _0154_ net85 _0339_ VGND VGND VPWR VPWR _0340_ sky130_fd_sc_hd__mux2_1
XFILLER_0_35_245 VGND VGND VPWR VPWR sky130_fd_sc_hd__fill_2
XFILLER_0_35_234 VGND VGND VPWR VPWR sky130_fd_sc_hd__fill_2
Xoutput20 net20 VGND VGND VPWR VPWR rd_data[5] sky130_fd_sc_hd__clkbuf_4
XTAP_145 VGND VPWR sky130_fd_sc_hd__tapvpwrvgnd_1
XTAP_134 VGND VPWR sky130_fd_sc_hd__tapvpwrvgnd_1
XTAP_123 VGND VPWR sky130_fd_sc_hd__tapvpwrvgnd_1
XTAP_112 VGND VPWR sky130_fd_sc_hd__tapvpwrvgnd_1
XTAP_156 VGND VPWR sky130_fd_sc_hd__tapvpwrvgnd_1
XTAP_167 VGND VPWR sky130_fd_sc_hd__tapvpwrvgnd_1
XTAP_178 VGND VPWR sky130_fd_sc_hd__tapvpwrvgnd_1
XTAP_189 VGND VPWR sky130_fd_sc_hd__tapvpwrvgnd_1
X_0504_ write_pointer\[1\] net2 _0188_ VGND VGND VPWR VPWR _0189_ sky130_fd_sc_hd__and3b_4
XFILLER_0_17_223 VGND VGND VPWR VPWR sky130_fd_sc_hd__fill_1
XFILLER_0_17_278 VGND VGND VPWR VPWR sky130_fd_sc_hd__fill_2
XFILLER_0_4_161 VGND VGND VPWR VPWR sky130_fd_sc_hd__decap_8
XFILLER_0_48_27 VGND VGND VPWR VPWR sky130_fd_sc_hd__fill_1
X_0984_ clknet_4_1_0_clk _0088_ VGND VGND VPWR VPWR memory\[9\]\[7\] sky130_fd_sc_hd__dfxtp_1
XFILLER_0_14_237 VGND VGND VPWR VPWR sky130_fd_sc_hd__fill_2
XFILLER_0_22_281 VPWR VGND VPWR VGND sky130_ef_sc_hd__decap_12
XFILLER_0_1_197 VGND VGND VPWR VPWR sky130_fd_sc_hd__fill_2
XFILLER_0_49_145 VGND VGND VPWR VPWR sky130_fd_sc_hd__decap_4
XFILLER_0_13_281 VPWR VGND VPWR VGND sky130_ef_sc_hd__decap_12
XFILLER_0_34_29 VPWR VGND VPWR VGND sky130_ef_sc_hd__decap_12
XFILLER_0_46_137 VGND VGND VPWR VPWR sky130_fd_sc_hd__decap_3
XFILLER_0_6_289 VPWR VGND VPWR VGND sky130_ef_sc_hd__decap_12
X_0967_ clknet_4_0_0_clk _0071_ VGND VGND VPWR VPWR memory\[14\]\[6\] sky130_fd_sc_hd__dfxtp_1
X_0898_ clknet_4_8_0_clk _0002_ VGND VGND VPWR VPWR memory\[15\]\[2\] sky130_fd_sc_hd__dfxtp_1
XFILLER_0_37_148 VPWR VGND VPWR VGND sky130_ef_sc_hd__decap_12
XFILLER_0_37_104 VGND VGND VPWR VPWR sky130_fd_sc_hd__decap_8
XFILLER_0_45_181 VPWR VGND VPWR VGND sky130_ef_sc_hd__decap_12
XFILLER_0_45_39 VPWR VGND VPWR VGND sky130_ef_sc_hd__decap_12
XFILLER_0_9_39 VPWR VGND VPWR VGND sky130_ef_sc_hd__decap_12
X_0821_ _0394_ VGND VGND VPWR VPWR _0128_ sky130_fd_sc_hd__clkbuf_1
X_0752_ _0199_ _0299_ VGND VGND VPWR VPWR _0357_ sky130_fd_sc_hd__and2_1
X_0683_ _0154_ net136 _0319_ VGND VGND VPWR VPWR _0320_ sky130_fd_sc_hd__mux2_1
XFILLER_0_3_237 VPWR VGND VPWR VGND sky130_ef_sc_hd__decap_12
XFILLER_0_36_7 VGND VGND VPWR VPWR sky130_fd_sc_hd__decap_4
XFILLER_0_51_93 VGND VGND VPWR VPWR sky130_fd_sc_hd__fill_1
XFILLER_0_27_192 VPWR VGND VPWR VGND sky130_ef_sc_hd__decap_12
XFILLER_0_31_19 VGND VGND VPWR VPWR sky130_fd_sc_hd__fill_2
Xclkbuf_4_11_0_clk clknet_0_clk VGND VGND VPWR VPWR clknet_4_11_0_clk sky130_fd_sc_hd__clkbuf_8
X_1020_ clknet_4_3_0_clk _0124_ VGND VGND VPWR VPWR memory\[8\]\[3\] sky130_fd_sc_hd__dfxtp_1
XFILLER_0_21_63 VGND VGND VPWR VPWR sky130_fd_sc_hd__fill_1
X_0804_ _0299_ _0328_ VGND VGND VPWR VPWR _0385_ sky130_fd_sc_hd__and2_1
X_0735_ _0177_ _0328_ VGND VGND VPWR VPWR _0348_ sky130_fd_sc_hd__nand2_4
X_0666_ net57 net3 _0310_ VGND VGND VPWR VPWR _0311_ sky130_fd_sc_hd__mux2_1
X_0597_ net163 _0221_ _0251_ _0255_ _0236_ VGND VGND VPWR VPWR _0043_ sky130_fd_sc_hd__o221a_1
XFILLER_0_1_51 VGND VGND VPWR VPWR sky130_fd_sc_hd__decap_4
XFILLER_0_27_3 VPWR VGND VPWR VGND sky130_ef_sc_hd__decap_12
Xhold86 memory\[1\]\[1\] VGND VGND VPWR VPWR net111 sky130_fd_sc_hd__dlygate4sd3_1
Xhold64 memory\[1\]\[7\] VGND VGND VPWR VPWR net89 sky130_fd_sc_hd__dlygate4sd3_1
Xhold75 memory\[4\]\[3\] VGND VGND VPWR VPWR net100 sky130_fd_sc_hd__dlygate4sd3_1
Xhold31 memory\[15\]\[1\] VGND VGND VPWR VPWR net56 sky130_fd_sc_hd__dlygate4sd3_1
Xhold97 memory\[10\]\[1\] VGND VGND VPWR VPWR net122 sky130_fd_sc_hd__dlygate4sd3_1
Xhold42 memory\[9\]\[4\] VGND VGND VPWR VPWR net67 sky130_fd_sc_hd__dlygate4sd3_1
Xhold53 memory\[8\]\[7\] VGND VGND VPWR VPWR net78 sky130_fd_sc_hd__dlygate4sd3_1
Xhold20 memory\[8\]\[3\] VGND VGND VPWR VPWR net45 sky130_fd_sc_hd__dlygate4sd3_1
XFILLER_0_42_29 VGND VGND VPWR VPWR sky130_fd_sc_hd__fill_2
XFILLER_0_21_121 VGND VGND VPWR VPWR sky130_fd_sc_hd__fill_1
XTAP_349 VGND VPWR sky130_fd_sc_hd__tapvpwrvgnd_1
XTAP_338 VGND VPWR sky130_fd_sc_hd__tapvpwrvgnd_1
XTAP_327 VGND VPWR sky130_fd_sc_hd__tapvpwrvgnd_1
XTAP_316 VGND VPWR sky130_fd_sc_hd__tapvpwrvgnd_1
XTAP_305 VGND VPWR sky130_fd_sc_hd__tapvpwrvgnd_1
X_0520_ _0174_ net127 _0190_ VGND VGND VPWR VPWR _0198_ sky130_fd_sc_hd__mux2_1
X_0451_ _0153_ VGND VGND VPWR VPWR net13 sky130_fd_sc_hd__dlymetal6s2s_1
X_1003_ clknet_4_14_0_clk _0107_ VGND VGND VPWR VPWR memory\[0\]\[2\] sky130_fd_sc_hd__dfxtp_1
XFILLER_0_16_41 VGND VGND VPWR VPWR sky130_fd_sc_hd__decap_8
XFILLER_0_16_74 VGND VGND VPWR VPWR sky130_fd_sc_hd__decap_8
XFILLER_0_44_235 VPWR VGND VPWR VGND sky130_ef_sc_hd__decap_12
XFILLER_0_32_51 VGND VGND VPWR VPWR sky130_fd_sc_hd__decap_8
X_0718_ _0189_ _0328_ VGND VGND VPWR VPWR _0339_ sky130_fd_sc_hd__nand2_4
X_0649_ net97 net3 _0301_ VGND VGND VPWR VPWR _0302_ sky130_fd_sc_hd__mux2_1
XFILLER_0_50_216 VPWR VGND VPWR VGND sky130_ef_sc_hd__decap_12
XFILLER_0_50_205 VGND VGND VPWR VPWR sky130_fd_sc_hd__decap_3
Xoutput21 net21 VGND VGND VPWR VPWR rd_data[6] sky130_fd_sc_hd__clkbuf_4
XFILLER_0_5_107 VGND VGND VPWR VPWR sky130_fd_sc_hd__decap_4
XFILLER_0_41_238 VGND VGND VPWR VPWR sky130_fd_sc_hd__fill_2
XTAP_146 VGND VPWR sky130_fd_sc_hd__tapvpwrvgnd_1
XTAP_135 VGND VPWR sky130_fd_sc_hd__tapvpwrvgnd_1
XTAP_124 VGND VPWR sky130_fd_sc_hd__tapvpwrvgnd_1
XTAP_113 VGND VPWR sky130_fd_sc_hd__tapvpwrvgnd_1
XTAP_157 VGND VPWR sky130_fd_sc_hd__tapvpwrvgnd_1
XTAP_168 VGND VPWR sky130_fd_sc_hd__tapvpwrvgnd_1
XTAP_179 VGND VPWR sky130_fd_sc_hd__tapvpwrvgnd_1
X_0503_ write_pointer\[0\] _0156_ VGND VGND VPWR VPWR _0188_ sky130_fd_sc_hd__and2_1
XFILLER_0_49_305 VGND VGND VPWR VPWR sky130_fd_sc_hd__fill_2
XFILLER_0_43_83 VGND VGND VPWR VPWR sky130_fd_sc_hd__fill_1
XFILLER_0_43_50 VGND VGND VPWR VPWR sky130_fd_sc_hd__fill_2
XFILLER_0_32_216 VPWR VGND VPWR VGND sky130_ef_sc_hd__decap_12
X_0983_ clknet_4_0_0_clk _0087_ VGND VGND VPWR VPWR memory\[9\]\[6\] sky130_fd_sc_hd__dfxtp_1
XFILLER_0_14_227 VGND VGND VPWR VPWR sky130_fd_sc_hd__fill_1
XFILLER_0_1_165 VGND VGND VPWR VPWR sky130_fd_sc_hd__decap_3
XFILLER_0_22_293 VPWR VGND VPWR VGND sky130_ef_sc_hd__decap_12
XFILLER_0_13_271 VGND VGND VPWR VPWR sky130_fd_sc_hd__decap_8
XFILLER_0_13_293 VPWR VGND VPWR VGND sky130_ef_sc_hd__decap_12
XFILLER_0_50_29 VPWR VGND VPWR VGND sky130_ef_sc_hd__decap_12
XFILLER_0_40_73 VGND VGND VPWR VPWR sky130_fd_sc_hd__fill_1
X_0897_ clknet_4_8_0_clk _0001_ VGND VGND VPWR VPWR memory\[15\]\[1\] sky130_fd_sc_hd__dfxtp_1
X_0966_ clknet_4_0_0_clk _0070_ VGND VGND VPWR VPWR memory\[14\]\[5\] sky130_fd_sc_hd__dfxtp_1
XFILLER_0_45_193 VGND VGND VPWR VPWR sky130_fd_sc_hd__decap_4
XFILLER_0_51_141 VGND VGND VPWR VPWR sky130_fd_sc_hd__decap_8
XFILLER_0_3_249 VPWR VGND VPWR VGND sky130_ef_sc_hd__decap_12
X_0751_ _0356_ VGND VGND VPWR VPWR _0096_ sky130_fd_sc_hd__clkbuf_1
X_0820_ net78 net10 _0386_ VGND VGND VPWR VPWR _0394_ sky130_fd_sc_hd__mux2_1
X_0682_ _0158_ _0177_ VGND VGND VPWR VPWR _0319_ sky130_fd_sc_hd__nand2_4
XFILLER_0_42_141 VGND VGND VPWR VPWR sky130_fd_sc_hd__decap_8
X_0949_ clknet_4_9_0_clk _0053_ VGND VGND VPWR VPWR memory\[12\]\[4\] sky130_fd_sc_hd__dfxtp_1
XFILLER_0_33_196 VGND VGND VPWR VPWR sky130_fd_sc_hd__decap_8
XFILLER_0_0_219 VGND VGND VPWR VPWR sky130_fd_sc_hd__decap_4
X_0803_ _0384_ VGND VGND VPWR VPWR _0120_ sky130_fd_sc_hd__clkbuf_1
XFILLER_0_24_141 VGND VGND VPWR VPWR sky130_fd_sc_hd__decap_6
X_0734_ _0347_ VGND VGND VPWR VPWR _0088_ sky130_fd_sc_hd__clkbuf_1
X_0665_ write_pointer\[3\] write_pointer\[2\] _0155_ _0157_ VGND VGND VPWR VPWR _0310_
+ sky130_fd_sc_hd__and4bb_4
X_0596_ _0222_ _0254_ _0229_ VGND VGND VPWR VPWR _0255_ sky130_fd_sc_hd__a21o_1
XFILLER_0_46_83 VGND VGND VPWR VPWR sky130_fd_sc_hd__fill_1
XFILLER_0_15_141 VGND VGND VPWR VPWR sky130_fd_sc_hd__fill_1
Xhold76 memory\[3\]\[3\] VGND VGND VPWR VPWR net101 sky130_fd_sc_hd__dlygate4sd3_1
Xhold32 memory\[3\]\[0\] VGND VGND VPWR VPWR net57 sky130_fd_sc_hd__dlygate4sd3_1
Xhold54 memory\[2\]\[5\] VGND VGND VPWR VPWR net79 sky130_fd_sc_hd__dlygate4sd3_1
Xhold65 memory\[7\]\[0\] VGND VGND VPWR VPWR net90 sky130_fd_sc_hd__dlygate4sd3_1
Xhold43 memory\[13\]\[0\] VGND VGND VPWR VPWR net68 sky130_fd_sc_hd__dlygate4sd3_1
Xhold21 net16 VGND VGND VPWR VPWR net46 sky130_fd_sc_hd__dlygate4sd3_1
Xhold98 memory\[10\]\[4\] VGND VGND VPWR VPWR net123 sky130_fd_sc_hd__dlygate4sd3_1
Xhold10 memory\[11\]\[4\] VGND VGND VPWR VPWR net35 sky130_fd_sc_hd__dlygate4sd3_1
Xhold87 memory\[5\]\[5\] VGND VGND VPWR VPWR net112 sky130_fd_sc_hd__dlygate4sd3_1
XFILLER_0_21_100 VPWR VGND VPWR VGND sky130_ef_sc_hd__decap_12
XTAP_339 VGND VPWR sky130_fd_sc_hd__tapvpwrvgnd_1
XTAP_328 VGND VPWR sky130_fd_sc_hd__tapvpwrvgnd_1
XTAP_317 VGND VPWR sky130_fd_sc_hd__tapvpwrvgnd_1
XTAP_306 VGND VPWR sky130_fd_sc_hd__tapvpwrvgnd_1
X_0450_ data_count\[4\] net25 VGND VGND VPWR VPWR _0153_ sky130_fd_sc_hd__and2_1
X_1002_ clknet_4_15_0_clk _0106_ VGND VGND VPWR VPWR memory\[0\]\[1\] sky130_fd_sc_hd__dfxtp_1
XFILLER_0_16_97 VGND VGND VPWR VPWR sky130_fd_sc_hd__fill_1
XFILLER_0_44_247 VGND VGND VPWR VPWR sky130_fd_sc_hd__decap_4
XFILLER_0_29_277 VGND VGND VPWR VPWR sky130_fd_sc_hd__decap_3
X_0717_ _0338_ VGND VGND VPWR VPWR _0080_ sky130_fd_sc_hd__clkbuf_1
X_0648_ _0300_ VGND VGND VPWR VPWR _0301_ sky130_fd_sc_hd__buf_4
X_0579_ memory\[4\]\[1\] memory\[5\]\[1\] memory\[6\]\[1\] memory\[7\]\[1\] _0231_
+ _0237_ VGND VGND VPWR VPWR _0239_ sky130_fd_sc_hd__mux4_1
XFILLER_0_50_228 VPWR VGND VPWR VGND sky130_ef_sc_hd__decap_12
Xclkbuf_4_10_0_clk clknet_0_clk VGND VGND VPWR VPWR clknet_4_10_0_clk sky130_fd_sc_hd__clkbuf_8
Xoutput22 net22 VGND VGND VPWR VPWR rd_data[7] sky130_fd_sc_hd__clkbuf_4
XFILLER_0_9_3 VPWR VGND VPWR VGND sky130_ef_sc_hd__decap_12
X_0502_ _0187_ VGND VGND VPWR VPWR _0016_ sky130_fd_sc_hd__clkbuf_1
XTAP_114 VGND VPWR sky130_fd_sc_hd__tapvpwrvgnd_1
XTAP_147 VGND VPWR sky130_fd_sc_hd__tapvpwrvgnd_1
XTAP_136 VGND VPWR sky130_fd_sc_hd__tapvpwrvgnd_1
XTAP_125 VGND VPWR sky130_fd_sc_hd__tapvpwrvgnd_1
XTAP_158 VGND VPWR sky130_fd_sc_hd__tapvpwrvgnd_1
XTAP_169 VGND VPWR sky130_fd_sc_hd__tapvpwrvgnd_1
XFILLER_0_32_228 VGND VGND VPWR VPWR sky130_fd_sc_hd__decap_8
XFILLER_0_40_250 VGND VGND VPWR VPWR sky130_fd_sc_hd__fill_2
XFILLER_0_48_29 VPWR VGND VPWR VGND sky130_ef_sc_hd__decap_12
X_0982_ clknet_4_0_0_clk _0086_ VGND VGND VPWR VPWR memory\[9\]\[5\] sky130_fd_sc_hd__dfxtp_1
XFILLER_0_38_51 VGND VGND VPWR VPWR sky130_fd_sc_hd__decap_8
XFILLER_0_1_111 VGND VGND VPWR VPWR sky130_fd_sc_hd__fill_1
XFILLER_0_1_133 VPWR VGND VPWR VGND sky130_ef_sc_hd__decap_12
XFILLER_0_22_250 VGND VGND VPWR VPWR sky130_fd_sc_hd__fill_2
XFILLER_0_49_169 VGND VGND VPWR VPWR sky130_fd_sc_hd__decap_3
XFILLER_0_9_266 VPWR VGND VPWR VGND sky130_ef_sc_hd__decap_12
XFILLER_0_20_209 VPWR VGND VPWR VGND sky130_ef_sc_hd__decap_12
XFILLER_0_6_214 VGND VGND VPWR VPWR sky130_fd_sc_hd__decap_3
XFILLER_0_24_97 VGND VGND VPWR VPWR sky130_fd_sc_hd__decap_4
XFILLER_0_40_41 VPWR VGND VPWR VGND sky130_ef_sc_hd__decap_12
X_0896_ clknet_4_2_0_clk _0000_ VGND VGND VPWR VPWR memory\[15\]\[0\] sky130_fd_sc_hd__dfxtp_1
X_0965_ clknet_4_3_0_clk _0069_ VGND VGND VPWR VPWR memory\[14\]\[4\] sky130_fd_sc_hd__dfxtp_1
XFILLER_0_4_85 VPWR VGND VPWR VGND sky130_ef_sc_hd__decap_12
XFILLER_0_51_197 VGND VGND VPWR VPWR sky130_fd_sc_hd__decap_8
X_0681_ _0318_ VGND VGND VPWR VPWR _0064_ sky130_fd_sc_hd__clkbuf_1
X_0750_ _0174_ net104 _0348_ VGND VGND VPWR VPWR _0356_ sky130_fd_sc_hd__mux2_1
XFILLER_0_34_109 VGND VGND VPWR VPWR sky130_fd_sc_hd__decap_8
X_0948_ clknet_4_1_0_clk _0052_ VGND VGND VPWR VPWR memory\[12\]\[3\] sky130_fd_sc_hd__dfxtp_1
XFILLER_0_42_197 VGND VGND VPWR VPWR sky130_fd_sc_hd__fill_2
X_0879_ data_count\[2\] _0427_ _0424_ _0429_ VGND VGND VPWR VPWR _0432_ sky130_fd_sc_hd__a22o_1
XFILLER_0_0_209 VGND VGND VPWR VPWR sky130_fd_sc_hd__decap_4
XFILLER_0_18_183 VGND VGND VPWR VPWR sky130_fd_sc_hd__fill_1
XFILLER_0_21_304 VGND VGND VPWR VPWR sky130_fd_sc_hd__decap_3
X_0802_ _0174_ net148 _0376_ VGND VGND VPWR VPWR _0384_ sky130_fd_sc_hd__mux2_1
XFILLER_0_12_304 VGND VGND VPWR VPWR sky130_fd_sc_hd__decap_3
X_0664_ _0309_ VGND VGND VPWR VPWR _0056_ sky130_fd_sc_hd__clkbuf_1
X_0733_ _0174_ net142 _0339_ VGND VGND VPWR VPWR _0347_ sky130_fd_sc_hd__mux2_1
XFILLER_0_24_197 VPWR VGND VPWR VGND sky130_ef_sc_hd__decap_12
X_0595_ _0252_ _0253_ _0227_ VGND VGND VPWR VPWR _0254_ sky130_fd_sc_hd__mux2_1
XFILLER_0_47_223 VGND VGND VPWR VPWR sky130_fd_sc_hd__fill_1
Xhold22 memory\[0\]\[0\] VGND VGND VPWR VPWR net47 sky130_fd_sc_hd__dlygate4sd3_1
Xhold11 memory\[11\]\[0\] VGND VGND VPWR VPWR net36 sky130_fd_sc_hd__dlygate4sd3_1
Xhold99 memory\[2\]\[3\] VGND VGND VPWR VPWR net124 sky130_fd_sc_hd__dlygate4sd3_1
Xhold44 memory\[5\]\[4\] VGND VGND VPWR VPWR net69 sky130_fd_sc_hd__dlygate4sd3_1
Xhold77 memory\[1\]\[2\] VGND VGND VPWR VPWR net102 sky130_fd_sc_hd__dlygate4sd3_1
Xhold55 memory\[2\]\[2\] VGND VGND VPWR VPWR net80 sky130_fd_sc_hd__dlygate4sd3_1
Xhold66 memory\[4\]\[6\] VGND VGND VPWR VPWR net91 sky130_fd_sc_hd__dlygate4sd3_1
Xhold88 memory\[15\]\[2\] VGND VGND VPWR VPWR net113 sky130_fd_sc_hd__dlygate4sd3_1
Xhold33 memory\[8\]\[1\] VGND VGND VPWR VPWR net58 sky130_fd_sc_hd__dlygate4sd3_1
XFILLER_0_21_134 VGND VGND VPWR VPWR sky130_fd_sc_hd__decap_8
XFILLER_0_21_167 VGND VGND VPWR VPWR sky130_fd_sc_hd__fill_1
XTAP_329 VGND VPWR sky130_fd_sc_hd__tapvpwrvgnd_1
XTAP_318 VGND VPWR sky130_fd_sc_hd__tapvpwrvgnd_1
XTAP_307 VGND VPWR sky130_fd_sc_hd__tapvpwrvgnd_1
X_1001_ clknet_4_12_0_clk _0105_ VGND VGND VPWR VPWR memory\[0\]\[0\] sky130_fd_sc_hd__dfxtp_1
XFILLER_0_8_106 VGND VGND VPWR VPWR sky130_fd_sc_hd__fill_2
XFILLER_0_16_21 VGND VGND VPWR VPWR sky130_fd_sc_hd__decap_6
XFILLER_0_29_245 VPWR VGND VPWR VGND sky130_ef_sc_hd__decap_12
XFILLER_0_4_301 VGND VGND VPWR VPWR sky130_fd_sc_hd__decap_6
X_0578_ memory\[0\]\[1\] memory\[1\]\[1\] memory\[2\]\[1\] memory\[3\]\[1\] _0231_
+ _0237_ VGND VGND VPWR VPWR _0238_ sky130_fd_sc_hd__mux4_1
X_0716_ net41 net10 _0330_ VGND VGND VPWR VPWR _0338_ sky130_fd_sc_hd__mux2_1
X_0647_ _0158_ _0299_ VGND VGND VPWR VPWR _0300_ sky130_fd_sc_hd__and2_1
XFILLER_0_32_3 VPWR VGND VPWR VGND sky130_ef_sc_hd__decap_12
XFILLER_0_43_281 VPWR VGND VPWR VGND sky130_ef_sc_hd__decap_12
Xoutput23 net23 VGND VGND VPWR VPWR underflow sky130_fd_sc_hd__clkbuf_4
Xoutput12 net12 VGND VGND VPWR VPWR empty sky130_fd_sc_hd__clkbuf_4
X_0501_ _0174_ net153 _0179_ VGND VGND VPWR VPWR _0187_ sky130_fd_sc_hd__mux2_1
XFILLER_0_34_281 VGND VGND VPWR VPWR sky130_fd_sc_hd__fill_1
XTAP_148 VGND VPWR sky130_fd_sc_hd__tapvpwrvgnd_1
XTAP_137 VGND VPWR sky130_fd_sc_hd__tapvpwrvgnd_1
XTAP_126 VGND VPWR sky130_fd_sc_hd__tapvpwrvgnd_1
XTAP_104 VGND VPWR sky130_fd_sc_hd__tapvpwrvgnd_1
XTAP_115 VGND VPWR sky130_fd_sc_hd__tapvpwrvgnd_1
XTAP_159 VGND VPWR sky130_fd_sc_hd__tapvpwrvgnd_1
XFILLER_0_27_53 VGND VGND VPWR VPWR sky130_fd_sc_hd__decap_3
XFILLER_0_27_97 VGND VGND VPWR VPWR sky130_fd_sc_hd__fill_1
XFILLER_0_4_197 VGND VGND VPWR VPWR sky130_fd_sc_hd__fill_1
XFILLER_0_23_229 VPWR VGND VPWR VGND sky130_ef_sc_hd__decap_12
XFILLER_0_13_11 VGND VGND VPWR VPWR sky130_fd_sc_hd__fill_1
XFILLER_0_13_55 VGND VGND VPWR VPWR sky130_fd_sc_hd__fill_1
X_0981_ clknet_4_10_0_clk _0085_ VGND VGND VPWR VPWR memory\[9\]\[4\] sky130_fd_sc_hd__dfxtp_1
XFILLER_0_1_101 VGND VGND VPWR VPWR sky130_fd_sc_hd__fill_2
XFILLER_0_1_145 VPWR VGND VPWR VGND sky130_ef_sc_hd__decap_12
XFILLER_0_9_278 VGND VGND VPWR VPWR sky130_fd_sc_hd__fill_2
Xhold130 memory\[2\]\[0\] VGND VGND VPWR VPWR net155 sky130_fd_sc_hd__dlygate4sd3_1
XFILLER_0_48_192 VGND VGND VPWR VPWR sky130_fd_sc_hd__fill_1
XFILLER_0_46_129 VGND VGND VPWR VPWR sky130_fd_sc_hd__decap_8
XFILLER_0_39_192 VPWR VGND VPWR VGND sky130_ef_sc_hd__decap_12
XFILLER_0_40_53 VPWR VGND VPWR VGND sky130_ef_sc_hd__decap_12
X_0964_ clknet_4_1_0_clk _0068_ VGND VGND VPWR VPWR memory\[14\]\[3\] sky130_fd_sc_hd__dfxtp_1
XFILLER_0_49_73 VGND VGND VPWR VPWR sky130_fd_sc_hd__fill_2
XFILLER_0_49_51 VGND VGND VPWR VPWR sky130_fd_sc_hd__decap_4
X_0895_ _0442_ _0443_ _0444_ _0446_ _0236_ VGND VGND VPWR VPWR _0150_ sky130_fd_sc_hd__o311a_1
XFILLER_0_4_97 VGND VGND VPWR VPWR sky130_fd_sc_hd__decap_3
XFILLER_0_45_162 VGND VGND VPWR VPWR sky130_fd_sc_hd__decap_6
XFILLER_0_5_281 VPWR VGND VPWR VGND sky130_ef_sc_hd__decap_12
XFILLER_0_51_154 VPWR VGND VPWR VGND sky130_ef_sc_hd__decap_12
X_0680_ net61 net10 _0310_ VGND VGND VPWR VPWR _0318_ sky130_fd_sc_hd__mux2_1
XFILLER_0_36_195 VGND VGND VPWR VPWR sky130_fd_sc_hd__fill_1
XFILLER_0_35_53 VGND VGND VPWR VPWR sky130_fd_sc_hd__decap_3
XFILLER_0_51_85 VGND VGND VPWR VPWR sky130_fd_sc_hd__decap_8
XFILLER_0_42_132 VGND VGND VPWR VPWR sky130_fd_sc_hd__decap_8
X_0947_ clknet_4_8_0_clk _0051_ VGND VGND VPWR VPWR memory\[12\]\[2\] sky130_fd_sc_hd__dfxtp_1
X_0878_ _0296_ _0431_ VGND VGND VPWR VPWR _0148_ sky130_fd_sc_hd__nor2_1
XFILLER_0_33_165 VGND VGND VPWR VPWR sky130_fd_sc_hd__decap_3
XFILLER_0_18_173 VGND VGND VPWR VPWR sky130_fd_sc_hd__fill_1
XFILLER_0_18_195 VGND VGND VPWR VPWR sky130_fd_sc_hd__fill_1
X_0801_ _0383_ VGND VGND VPWR VPWR _0119_ sky130_fd_sc_hd__clkbuf_1
XFILLER_0_21_11 VGND VGND VPWR VPWR sky130_fd_sc_hd__fill_1
XFILLER_0_21_33 VGND VGND VPWR VPWR sky130_fd_sc_hd__decap_3
XFILLER_0_21_55 VGND VGND VPWR VPWR sky130_fd_sc_hd__fill_1
XFILLER_0_21_77 VGND VGND VPWR VPWR sky130_fd_sc_hd__decap_6
XFILLER_0_24_154 VGND VGND VPWR VPWR sky130_fd_sc_hd__fill_1
X_0594_ memory\[12\]\[2\] memory\[13\]\[2\] memory\[14\]\[2\] memory\[15\]\[2\] _0223_
+ _0224_ VGND VGND VPWR VPWR _0253_ sky130_fd_sc_hd__mux4_1
X_0732_ _0346_ VGND VGND VPWR VPWR _0087_ sky130_fd_sc_hd__clkbuf_1
X_0663_ net115 net10 _0301_ VGND VGND VPWR VPWR _0309_ sky130_fd_sc_hd__mux2_1
XFILLER_0_46_85 VPWR VGND VPWR VGND sky130_ef_sc_hd__decap_12
XFILLER_0_47_279 VGND VGND VPWR VPWR sky130_fd_sc_hd__fill_1
Xhold34 memory\[0\]\[7\] VGND VGND VPWR VPWR net59 sky130_fd_sc_hd__dlygate4sd3_1
Xhold45 memory\[7\]\[1\] VGND VGND VPWR VPWR net70 sky130_fd_sc_hd__dlygate4sd3_1
Xhold12 memory\[0\]\[2\] VGND VGND VPWR VPWR net37 sky130_fd_sc_hd__dlygate4sd3_1
Xhold56 memory\[0\]\[6\] VGND VGND VPWR VPWR net81 sky130_fd_sc_hd__dlygate4sd3_1
Xhold23 memory\[15\]\[4\] VGND VGND VPWR VPWR net48 sky130_fd_sc_hd__dlygate4sd3_1
Xhold67 memory\[6\]\[0\] VGND VGND VPWR VPWR net92 sky130_fd_sc_hd__dlygate4sd3_1
Xhold78 memory\[13\]\[2\] VGND VGND VPWR VPWR net103 sky130_fd_sc_hd__dlygate4sd3_1
Xhold89 memory\[13\]\[6\] VGND VGND VPWR VPWR net114 sky130_fd_sc_hd__dlygate4sd3_1
XTAP_319 VGND VPWR sky130_fd_sc_hd__tapvpwrvgnd_1
XTAP_308 VGND VPWR sky130_fd_sc_hd__tapvpwrvgnd_1
XFILLER_0_21_113 VGND VGND VPWR VPWR sky130_fd_sc_hd__decap_8
X_1000_ clknet_4_5_0_clk _0104_ VGND VGND VPWR VPWR memory\[4\]\[7\] sky130_fd_sc_hd__dfxtp_1
XFILLER_0_29_257 VPWR VGND VPWR VGND sky130_ef_sc_hd__decap_12
X_0715_ _0337_ VGND VGND VPWR VPWR _0079_ sky130_fd_sc_hd__clkbuf_1
X_0577_ read_pointer\[1\] VGND VGND VPWR VPWR _0237_ sky130_fd_sc_hd__clkbuf_4
X_0646_ _0298_ VGND VGND VPWR VPWR _0299_ sky130_fd_sc_hd__inv_2
Xoutput13 net13 VGND VGND VPWR VPWR full sky130_fd_sc_hd__clkbuf_4
XFILLER_0_43_293 VPWR VGND VPWR VGND sky130_ef_sc_hd__decap_12
XFILLER_0_1_305 VGND VGND VPWR VPWR sky130_fd_sc_hd__fill_2
X_0500_ _0186_ VGND VGND VPWR VPWR _0015_ sky130_fd_sc_hd__clkbuf_1
XTAP_149 VGND VPWR sky130_fd_sc_hd__tapvpwrvgnd_1
XTAP_138 VGND VPWR sky130_fd_sc_hd__tapvpwrvgnd_1
XTAP_127 VGND VPWR sky130_fd_sc_hd__tapvpwrvgnd_1
XTAP_105 VGND VPWR sky130_fd_sc_hd__tapvpwrvgnd_1
XTAP_116 VGND VPWR sky130_fd_sc_hd__tapvpwrvgnd_1
XFILLER_0_43_75 VGND VGND VPWR VPWR sky130_fd_sc_hd__decap_8
XFILLER_0_40_230 VPWR VGND VPWR VGND sky130_ef_sc_hd__decap_12
XFILLER_0_7_42 VPWR VGND VPWR VGND sky130_ef_sc_hd__decap_12
X_0629_ memory\[8\]\[6\] memory\[9\]\[6\] memory\[10\]\[6\] memory\[11\]\[6\] _0242_
+ _0243_ VGND VGND VPWR VPWR _0284_ sky130_fd_sc_hd__mux4_1
XFILLER_0_13_34 VGND VGND VPWR VPWR sky130_fd_sc_hd__fill_1
X_0980_ clknet_4_3_0_clk _0084_ VGND VGND VPWR VPWR memory\[9\]\[3\] sky130_fd_sc_hd__dfxtp_1
XFILLER_0_1_113 VPWR VGND VPWR VGND sky130_ef_sc_hd__decap_12
XFILLER_0_1_157 VGND VGND VPWR VPWR sky130_fd_sc_hd__decap_8
XFILLER_0_49_149 VGND VGND VPWR VPWR sky130_fd_sc_hd__fill_1
XFILLER_0_0_9 VPWR VGND VPWR VGND sky130_ef_sc_hd__decap_12
Xhold120 memory\[10\]\[6\] VGND VGND VPWR VPWR net145 sky130_fd_sc_hd__dlygate4sd3_1
Xhold131 net15 VGND VGND VPWR VPWR net156 sky130_fd_sc_hd__dlygate4sd3_1
XFILLER_0_40_65 VGND VGND VPWR VPWR sky130_fd_sc_hd__decap_8
X_0963_ clknet_4_8_0_clk _0067_ VGND VGND VPWR VPWR memory\[14\]\[2\] sky130_fd_sc_hd__dfxtp_1
X_0894_ _0440_ _0427_ _0428_ _0441_ _0445_ VGND VGND VPWR VPWR _0446_ sky130_fd_sc_hd__a221o_1
XFILLER_0_24_77 VGND VGND VPWR VPWR sky130_fd_sc_hd__decap_6
XFILLER_0_18_300 VGND VGND VPWR VPWR sky130_fd_sc_hd__decap_6
XFILLER_0_5_293 VPWR VGND VPWR VGND sky130_ef_sc_hd__decap_12
XFILLER_0_51_100 VPWR VGND VPWR VGND sky130_ef_sc_hd__decap_12
XFILLER_0_36_141 VPWR VGND VPWR VGND sky130_ef_sc_hd__decap_12
XFILLER_0_51_166 VGND VGND VPWR VPWR sky130_fd_sc_hd__fill_2
XFILLER_0_19_22 VGND VGND VPWR VPWR sky130_fd_sc_hd__fill_2
XFILLER_0_51_42 VPWR VGND VPWR VGND sky130_ef_sc_hd__decap_12
X_0946_ clknet_4_8_0_clk _0050_ VGND VGND VPWR VPWR memory\[12\]\[1\] sky130_fd_sc_hd__dfxtp_1
X_0877_ _0428_ _0430_ VGND VGND VPWR VPWR _0431_ sky130_fd_sc_hd__xnor2_1
XFILLER_0_33_177 VGND VGND VPWR VPWR sky130_fd_sc_hd__fill_2
X_0800_ _0172_ net52 _0376_ VGND VGND VPWR VPWR _0383_ sky130_fd_sc_hd__mux2_1
X_0731_ _0172_ net125 _0339_ VGND VGND VPWR VPWR _0346_ sky130_fd_sc_hd__mux2_1
XFILLER_0_21_67 VGND VGND VPWR VPWR sky130_fd_sc_hd__fill_1
X_0593_ memory\[8\]\[2\] memory\[9\]\[2\] memory\[10\]\[2\] memory\[11\]\[2\] _0242_
+ _0243_ VGND VGND VPWR VPWR _0252_ sky130_fd_sc_hd__mux4_1
X_0662_ _0308_ VGND VGND VPWR VPWR _0055_ sky130_fd_sc_hd__clkbuf_1
XFILLER_0_46_97 VGND VGND VPWR VPWR sky130_fd_sc_hd__decap_6
XFILLER_0_46_53 VGND VGND VPWR VPWR sky130_fd_sc_hd__fill_1
XFILLER_0_1_55 VGND VGND VPWR VPWR sky130_fd_sc_hd__fill_1
XFILLER_0_47_225 VPWR VGND VPWR VGND sky130_ef_sc_hd__decap_12
X_0929_ clknet_4_6_0_clk _0033_ VGND VGND VPWR VPWR memory\[1\]\[0\] sky130_fd_sc_hd__dfxtp_1
XFILLER_0_15_177 VGND VGND VPWR VPWR sky130_fd_sc_hd__decap_8
XFILLER_0_30_114 VGND VGND VPWR VPWR sky130_fd_sc_hd__decap_6
Xhold68 memory\[3\]\[1\] VGND VGND VPWR VPWR net93 sky130_fd_sc_hd__dlygate4sd3_1
Xhold57 memory\[8\]\[0\] VGND VGND VPWR VPWR net82 sky130_fd_sc_hd__dlygate4sd3_1
Xhold46 memory\[12\]\[1\] VGND VGND VPWR VPWR net71 sky130_fd_sc_hd__dlygate4sd3_1
Xhold79 memory\[10\]\[7\] VGND VGND VPWR VPWR net104 sky130_fd_sc_hd__dlygate4sd3_1
Xhold35 memory\[4\]\[5\] VGND VGND VPWR VPWR net60 sky130_fd_sc_hd__dlygate4sd3_1
Xhold24 memory\[0\]\[5\] VGND VGND VPWR VPWR net49 sky130_fd_sc_hd__dlygate4sd3_1
Xhold13 memory\[4\]\[0\] VGND VGND VPWR VPWR net38 sky130_fd_sc_hd__dlygate4sd3_1
XFILLER_0_38_214 VGND VGND VPWR VPWR sky130_fd_sc_hd__decap_6
XTAP_309 VGND VPWR sky130_fd_sc_hd__tapvpwrvgnd_1
XFILLER_0_21_169 VPWR VGND VPWR VGND sky130_ef_sc_hd__decap_12
XFILLER_0_29_225 VGND VGND VPWR VPWR sky130_fd_sc_hd__fill_1
XFILLER_0_29_269 VGND VGND VPWR VPWR sky130_fd_sc_hd__decap_8
X_0714_ net129 net9 _0330_ VGND VGND VPWR VPWR _0337_ sky130_fd_sc_hd__mux2_1
X_0645_ write_pointer\[1\] write_pointer\[0\] _0296_ _0297_ VGND VGND VPWR VPWR _0298_
+ sky130_fd_sc_hd__or4_2
X_0576_ net156 _0221_ _0230_ _0235_ _0236_ VGND VGND VPWR VPWR _0041_ sky130_fd_sc_hd__o221a_1
XFILLER_0_18_3 VGND VGND VPWR VPWR sky130_fd_sc_hd__decap_3
Xoutput14 net14 VGND VGND VPWR VPWR overflow sky130_fd_sc_hd__buf_2
XTAP_139 VGND VPWR sky130_fd_sc_hd__tapvpwrvgnd_1
XTAP_128 VGND VPWR sky130_fd_sc_hd__tapvpwrvgnd_1
XTAP_106 VGND VPWR sky130_fd_sc_hd__tapvpwrvgnd_1
XTAP_117 VGND VPWR sky130_fd_sc_hd__tapvpwrvgnd_1
XPHY_0 VGND VGND VPWR VPWR sky130_fd_sc_hd__decap_3
XFILLER_0_40_253 VPWR VGND VPWR VGND sky130_ef_sc_hd__decap_12
XFILLER_0_40_242 VGND VGND VPWR VPWR sky130_fd_sc_hd__decap_8
XFILLER_0_7_87 VGND VGND VPWR VPWR sky130_fd_sc_hd__fill_1
XFILLER_0_7_54 VGND VGND VPWR VPWR sky130_fd_sc_hd__fill_2
XFILLER_0_7_21 VGND VGND VPWR VPWR sky130_fd_sc_hd__fill_1
X_0628_ read_pointer\[3\] _0282_ VGND VGND VPWR VPWR _0283_ sky130_fd_sc_hd__and2b_1
X_0559_ data_count\[4\] _0151_ net1 VGND VGND VPWR VPWR _0220_ sky130_fd_sc_hd__o21a_2
XFILLER_0_16_250 VGND VGND VPWR VPWR sky130_fd_sc_hd__fill_2
XFILLER_0_31_253 VPWR VGND VPWR VGND sky130_ef_sc_hd__decap_12
XFILLER_0_7_3 VPWR VGND VPWR VGND sky130_ef_sc_hd__decap_12
XFILLER_0_14_209 VGND VGND VPWR VPWR sky130_fd_sc_hd__decap_4
XFILLER_0_38_21 VGND VGND VPWR VPWR sky130_fd_sc_hd__decap_6
XFILLER_0_1_125 VGND VGND VPWR VPWR sky130_fd_sc_hd__decap_4
XFILLER_0_9_225 VGND VGND VPWR VPWR sky130_fd_sc_hd__fill_1
Xhold110 memory\[9\]\[5\] VGND VGND VPWR VPWR net135 sky130_fd_sc_hd__dlygate4sd3_1
Xhold132 memory\[14\]\[7\] VGND VGND VPWR VPWR net157 sky130_fd_sc_hd__dlygate4sd3_1
Xhold121 memory\[10\]\[3\] VGND VGND VPWR VPWR net146 sky130_fd_sc_hd__dlygate4sd3_1
XFILLER_0_24_23 VGND VGND VPWR VPWR sky130_fd_sc_hd__decap_4
XFILLER_0_39_183 VGND VGND VPWR VPWR sky130_fd_sc_hd__fill_1
XFILLER_0_6_239 VPWR VGND VPWR VGND sky130_ef_sc_hd__decap_12
XFILLER_0_6_206 VGND VGND VPWR VPWR sky130_fd_sc_hd__decap_8
X_0962_ clknet_4_8_0_clk _0066_ VGND VGND VPWR VPWR memory\[14\]\[1\] sky130_fd_sc_hd__dfxtp_1
X_0893_ data_count\[4\] _0427_ VGND VGND VPWR VPWR _0445_ sky130_fd_sc_hd__xor2_1
XFILLER_0_4_33 VGND VGND VPWR VPWR sky130_fd_sc_hd__fill_1
XFILLER_0_10_256 VPWR VGND VPWR VGND sky130_ef_sc_hd__decap_12
XFILLER_0_28_109 VPWR VGND VPWR VGND sky130_ef_sc_hd__decap_12
XFILLER_0_36_153 VGND VGND VPWR VPWR sky130_fd_sc_hd__decap_6
XFILLER_0_19_67 VGND VGND VPWR VPWR sky130_fd_sc_hd__decap_3
XFILLER_0_51_54 VGND VGND VPWR VPWR sky130_fd_sc_hd__fill_2
XFILLER_0_42_178 VGND VGND VPWR VPWR sky130_fd_sc_hd__fill_2
XFILLER_0_2_253 VPWR VGND VPWR VGND sky130_ef_sc_hd__decap_12
X_0945_ clknet_4_2_0_clk _0049_ VGND VGND VPWR VPWR memory\[12\]\[0\] sky130_fd_sc_hd__dfxtp_1
X_0876_ _0419_ _0424_ _0429_ VGND VGND VPWR VPWR _0430_ sky130_fd_sc_hd__and3_1
XFILLER_0_27_186 VGND VGND VPWR VPWR sky130_fd_sc_hd__fill_1
XFILLER_0_48_3 VPWR VGND VPWR VGND sky130_ef_sc_hd__decap_12
XFILLER_0_18_197 VPWR VGND VPWR VGND sky130_ef_sc_hd__decap_12
X_0730_ _0345_ VGND VGND VPWR VPWR _0086_ sky130_fd_sc_hd__clkbuf_1
X_0661_ net96 net9 _0301_ VGND VGND VPWR VPWR _0308_ sky130_fd_sc_hd__mux2_1
XFILLER_0_21_57 VGND VGND VPWR VPWR sky130_fd_sc_hd__decap_6
XFILLER_0_24_101 VGND VGND VPWR VPWR sky130_fd_sc_hd__fill_1
X_0592_ read_pointer\[3\] _0250_ VGND VGND VPWR VPWR _0251_ sky130_fd_sc_hd__and2b_1
XFILLER_0_47_237 VPWR VGND VPWR VGND sky130_ef_sc_hd__decap_12
X_0928_ clknet_4_5_0_clk _0032_ VGND VGND VPWR VPWR memory\[7\]\[7\] sky130_fd_sc_hd__dfxtp_1
XFILLER_0_15_167 VGND VGND VPWR VPWR sky130_fd_sc_hd__fill_1
X_0859_ _0415_ _0155_ _0416_ VGND VGND VPWR VPWR _0417_ sky130_fd_sc_hd__and3b_1
Xhold36 memory\[3\]\[7\] VGND VGND VPWR VPWR net61 sky130_fd_sc_hd__dlygate4sd3_1
Xhold58 memory\[2\]\[4\] VGND VGND VPWR VPWR net83 sky130_fd_sc_hd__dlygate4sd3_1
Xhold47 memory\[7\]\[3\] VGND VGND VPWR VPWR net72 sky130_fd_sc_hd__dlygate4sd3_1
Xhold69 memory\[7\]\[7\] VGND VGND VPWR VPWR net94 sky130_fd_sc_hd__dlygate4sd3_1
Xhold25 memory\[5\]\[2\] VGND VGND VPWR VPWR net50 sky130_fd_sc_hd__dlygate4sd3_1
Xhold14 memory\[1\]\[5\] VGND VGND VPWR VPWR net39 sky130_fd_sc_hd__dlygate4sd3_1
XFILLER_0_37_281 VPWR VGND VPWR VGND sky130_ef_sc_hd__decap_12
XFILLER_0_37_270 VGND VGND VPWR VPWR sky130_fd_sc_hd__decap_8
X_0713_ _0336_ VGND VGND VPWR VPWR _0078_ sky130_fd_sc_hd__clkbuf_1
XFILLER_0_12_126 VGND VGND VPWR VPWR sky130_fd_sc_hd__fill_1
XFILLER_0_12_159 VGND VGND VPWR VPWR sky130_fd_sc_hd__fill_1
X_0644_ data_count\[4\] _0152_ net11 VGND VGND VPWR VPWR _0297_ sky130_fd_sc_hd__a21bo_2
X_0575_ _0155_ VGND VGND VPWR VPWR _0236_ sky130_fd_sc_hd__clkbuf_4
XFILLER_0_7_175 VGND VGND VPWR VPWR sky130_fd_sc_hd__fill_1
Xoutput15 net15 VGND VGND VPWR VPWR rd_data[0] sky130_fd_sc_hd__buf_2
XFILLER_0_19_281 VGND VGND VPWR VPWR sky130_fd_sc_hd__decap_6
XTAP_129 VGND VPWR sky130_fd_sc_hd__tapvpwrvgnd_1
XTAP_107 VGND VPWR sky130_fd_sc_hd__tapvpwrvgnd_1
XTAP_118 VGND VPWR sky130_fd_sc_hd__tapvpwrvgnd_1
XFILLER_0_43_66 VGND VGND VPWR VPWR sky130_fd_sc_hd__fill_1
XFILLER_0_43_55 VGND VGND VPWR VPWR sky130_fd_sc_hd__fill_1
XPHY_1 VGND VGND VPWR VPWR sky130_fd_sc_hd__decap_3
X_0558_ _0219_ VGND VGND VPWR VPWR _0040_ sky130_fd_sc_hd__clkbuf_1
XFILLER_0_40_265 VPWR VGND VPWR VGND sky130_ef_sc_hd__decap_12
X_0627_ _0280_ _0281_ read_pointer\[2\] VGND VGND VPWR VPWR _0282_ sky130_fd_sc_hd__mux2_1
X_0489_ _0162_ net76 _0179_ VGND VGND VPWR VPWR _0181_ sky130_fd_sc_hd__mux2_1
XFILLER_0_30_3 VGND VGND VPWR VPWR sky130_fd_sc_hd__decap_8
XFILLER_0_31_265 VPWR VGND VPWR VGND sky130_ef_sc_hd__decap_12
Xhold122 memory\[6\]\[7\] VGND VGND VPWR VPWR net147 sky130_fd_sc_hd__dlygate4sd3_1
Xhold133 memory\[10\]\[5\] VGND VGND VPWR VPWR net158 sky130_fd_sc_hd__dlygate4sd3_1
Xhold111 memory\[14\]\[0\] VGND VGND VPWR VPWR net136 sky130_fd_sc_hd__dlygate4sd3_1
Xhold100 memory\[9\]\[6\] VGND VGND VPWR VPWR net125 sky130_fd_sc_hd__dlygate4sd3_1
XFILLER_0_0_181 VPWR VGND VPWR VGND sky130_ef_sc_hd__decap_12
X_0961_ clknet_4_2_0_clk _0065_ VGND VGND VPWR VPWR memory\[14\]\[0\] sky130_fd_sc_hd__dfxtp_1
XFILLER_0_42_305 VGND VGND VPWR VPWR sky130_fd_sc_hd__fill_2
XFILLER_0_6_229 VGND VGND VPWR VPWR sky130_fd_sc_hd__fill_2
X_0892_ data_count\[4\] net1 _0297_ VGND VGND VPWR VPWR _0444_ sky130_fd_sc_hd__and3_1
XFILLER_0_10_268 VPWR VGND VPWR VGND sky130_ef_sc_hd__decap_12
XFILLER_0_45_121 VPWR VGND VPWR VGND sky130_ef_sc_hd__decap_12
XFILLER_0_33_305 VGND VGND VPWR VPWR sky130_fd_sc_hd__fill_2
XTAP_290 VGND VPWR sky130_fd_sc_hd__tapvpwrvgnd_1
XFILLER_0_51_113 VPWR VGND VPWR VGND sky130_ef_sc_hd__decap_12
XFILLER_0_10_15 VGND VGND VPWR VPWR sky130_fd_sc_hd__fill_2
XFILLER_0_10_26 VGND VGND VPWR VPWR sky130_fd_sc_hd__fill_2
XFILLER_0_10_37 VPWR VGND VPWR VGND sky130_ef_sc_hd__decap_12
XFILLER_0_19_57 VGND VGND VPWR VPWR sky130_fd_sc_hd__fill_1
XFILLER_0_35_23 VGND VGND VPWR VPWR sky130_fd_sc_hd__decap_3
XFILLER_0_15_305 VGND VGND VPWR VPWR sky130_fd_sc_hd__fill_2
X_0944_ clknet_4_3_0_clk _0048_ VGND VGND VPWR VPWR net22 sky130_fd_sc_hd__dfxtp_1
XFILLER_0_27_121 VPWR VGND VPWR VGND sky130_ef_sc_hd__decap_12
XFILLER_0_27_165 VGND VGND VPWR VPWR sky130_fd_sc_hd__decap_3
XFILLER_0_42_168 VGND VGND VPWR VPWR sky130_fd_sc_hd__fill_2
XFILLER_0_2_265 VPWR VGND VPWR VGND sky130_ef_sc_hd__decap_12
X_0875_ data_count\[0\] _0423_ VGND VGND VPWR VPWR _0429_ sky130_fd_sc_hd__or2_1
XFILLER_0_33_113 VGND VGND VPWR VPWR sky130_fd_sc_hd__decap_4
XFILLER_0_18_187 VGND VGND VPWR VPWR sky130_fd_sc_hd__decap_8
X_0591_ _0248_ _0249_ read_pointer\[2\] VGND VGND VPWR VPWR _0250_ sky130_fd_sc_hd__mux2_1
X_0660_ _0307_ VGND VGND VPWR VPWR _0054_ sky130_fd_sc_hd__clkbuf_1
XFILLER_0_21_47 VGND VGND VPWR VPWR sky130_fd_sc_hd__decap_8
XFILLER_0_46_33 VPWR VGND VPWR VGND sky130_ef_sc_hd__decap_12
XFILLER_0_1_57 VPWR VGND VPWR VGND sky130_ef_sc_hd__decap_12
XFILLER_0_47_249 VPWR VGND VPWR VGND sky130_ef_sc_hd__decap_12
X_0927_ clknet_4_5_0_clk _0031_ VGND VGND VPWR VPWR memory\[7\]\[6\] sky130_fd_sc_hd__dfxtp_1
XFILLER_0_15_113 VPWR VGND VPWR VGND sky130_ef_sc_hd__decap_12
X_0858_ _0227_ _0412_ VGND VGND VPWR VPWR _0416_ sky130_fd_sc_hd__or2_1
X_0789_ _0377_ VGND VGND VPWR VPWR _0113_ sky130_fd_sc_hd__clkbuf_1
Xhold59 memory\[4\]\[7\] VGND VGND VPWR VPWR net84 sky130_fd_sc_hd__dlygate4sd3_1
Xhold37 memory\[4\]\[2\] VGND VGND VPWR VPWR net62 sky130_fd_sc_hd__dlygate4sd3_1
Xhold48 memory\[10\]\[2\] VGND VGND VPWR VPWR net73 sky130_fd_sc_hd__dlygate4sd3_1
Xhold15 memory\[15\]\[7\] VGND VGND VPWR VPWR net40 sky130_fd_sc_hd__dlygate4sd3_1
Xhold26 memory\[11\]\[3\] VGND VGND VPWR VPWR net51 sky130_fd_sc_hd__dlygate4sd3_1
XFILLER_0_29_216 VGND VGND VPWR VPWR sky130_fd_sc_hd__decap_8
XFILLER_0_37_293 VPWR VGND VPWR VGND sky130_ef_sc_hd__decap_12
X_0712_ net75 net8 _0330_ VGND VGND VPWR VPWR _0336_ sky130_fd_sc_hd__mux2_1
XFILLER_0_12_138 VGND VGND VPWR VPWR sky130_fd_sc_hd__fill_2
X_0574_ read_pointer\[3\] _0234_ VGND VGND VPWR VPWR _0235_ sky130_fd_sc_hd__and2b_1
X_0643_ net2 VGND VGND VPWR VPWR _0296_ sky130_fd_sc_hd__inv_2
XFILLER_0_7_121 VGND VGND VPWR VPWR sky130_fd_sc_hd__fill_2
XFILLER_0_43_263 VPWR VGND VPWR VGND sky130_ef_sc_hd__decap_12
XFILLER_0_7_154 VGND VGND VPWR VPWR sky130_fd_sc_hd__fill_1
Xoutput16 net16 VGND VGND VPWR VPWR rd_data[1] sky130_fd_sc_hd__clkbuf_4
XPHY_100 VGND VGND VPWR VPWR sky130_fd_sc_hd__decap_3
XFILLER_0_34_241 VGND VGND VPWR VPWR sky130_fd_sc_hd__decap_8
XFILLER_0_34_285 VPWR VGND VPWR VGND sky130_ef_sc_hd__decap_12
XTAP_119 VGND VPWR sky130_fd_sc_hd__tapvpwrvgnd_1
XTAP_108 VGND VPWR sky130_fd_sc_hd__tapvpwrvgnd_1
XFILLER_0_27_57 VPWR VGND VPWR VGND sky130_ef_sc_hd__decap_12
XPHY_2 VGND VGND VPWR VPWR sky130_fd_sc_hd__decap_3
Xclkbuf_0_clk clk VGND VGND VPWR VPWR clknet_0_clk sky130_fd_sc_hd__clkbuf_16
X_0557_ _0174_ net89 _0211_ VGND VGND VPWR VPWR _0219_ sky130_fd_sc_hd__mux2_1
XFILLER_0_40_277 VPWR VGND VPWR VGND sky130_ef_sc_hd__decap_12
X_0626_ memory\[4\]\[6\] memory\[5\]\[6\] memory\[6\]\[6\] memory\[7\]\[6\] read_pointer\[0\]
+ read_pointer\[1\] VGND VGND VPWR VPWR _0281_ sky130_fd_sc_hd__mux4_1
X_0488_ _0180_ VGND VGND VPWR VPWR _0009_ sky130_fd_sc_hd__clkbuf_1
XFILLER_0_23_3 VPWR VGND VPWR VGND sky130_ef_sc_hd__decap_12
XFILLER_0_31_200 VGND VGND VPWR VPWR sky130_fd_sc_hd__decap_3
XFILLER_0_13_15 VGND VGND VPWR VPWR sky130_fd_sc_hd__decap_3
XFILLER_0_38_78 VGND VGND VPWR VPWR sky130_fd_sc_hd__decap_6
Xhold123 memory\[5\]\[7\] VGND VGND VPWR VPWR net148 sky130_fd_sc_hd__dlygate4sd3_1
Xhold101 memory\[2\]\[6\] VGND VGND VPWR VPWR net126 sky130_fd_sc_hd__dlygate4sd3_1
Xhold112 memory\[6\]\[6\] VGND VGND VPWR VPWR net137 sky130_fd_sc_hd__dlygate4sd3_1
Xhold134 memory\[14\]\[6\] VGND VGND VPWR VPWR net159 sky130_fd_sc_hd__dlygate4sd3_1
X_0609_ _0264_ _0265_ read_pointer\[2\] VGND VGND VPWR VPWR _0266_ sky130_fd_sc_hd__mux2_1
XFILLER_0_0_193 VGND VGND VPWR VPWR sky130_fd_sc_hd__decap_3
XFILLER_0_48_141 VGND VGND VPWR VPWR sky130_fd_sc_hd__decap_4
X_0960_ clknet_4_5_0_clk _0064_ VGND VGND VPWR VPWR memory\[3\]\[7\] sky130_fd_sc_hd__dfxtp_1
XFILLER_0_49_55 VGND VGND VPWR VPWR sky130_fd_sc_hd__fill_1
XFILLER_0_10_225 VGND VGND VPWR VPWR sky130_fd_sc_hd__fill_1
X_0891_ data_count\[4\] _0427_ VGND VGND VPWR VPWR _0443_ sky130_fd_sc_hd__nor2_1
XFILLER_0_49_99 VGND VGND VPWR VPWR sky130_fd_sc_hd__decap_4
XFILLER_0_45_133 VPWR VGND VPWR VGND sky130_ef_sc_hd__decap_12
XFILLER_0_45_111 VGND VGND VPWR VPWR sky130_fd_sc_hd__fill_1
XFILLER_0_5_241 VPWR VGND VPWR VGND sky130_ef_sc_hd__decap_12
XTAP_291 VGND VPWR sky130_fd_sc_hd__tapvpwrvgnd_1
XTAP_280 VGND VPWR sky130_fd_sc_hd__tapvpwrvgnd_1
XFILLER_0_51_169 VPWR VGND VPWR VGND sky130_ef_sc_hd__decap_12
XFILLER_0_51_125 VPWR VGND VPWR VGND sky130_ef_sc_hd__decap_12
XFILLER_0_10_49 VPWR VGND VPWR VGND sky130_ef_sc_hd__decap_12
XFILLER_0_24_306 VGND VGND VPWR VPWR sky130_fd_sc_hd__fill_1
XFILLER_0_35_57 VGND VGND VPWR VPWR sky130_fd_sc_hd__fill_1
X_0943_ clknet_4_3_0_clk _0047_ VGND VGND VPWR VPWR net21 sky130_fd_sc_hd__dfxtp_1
X_0874_ data_count\[2\] _0427_ VGND VGND VPWR VPWR _0428_ sky130_fd_sc_hd__xor2_2
XFILLER_0_27_111 VGND VGND VPWR VPWR sky130_fd_sc_hd__fill_1
XFILLER_0_27_133 VPWR VGND VPWR VGND sky130_ef_sc_hd__decap_12
XFILLER_0_2_277 VPWR VGND VPWR VGND sky130_ef_sc_hd__decap_12
XFILLER_0_33_169 VGND VGND VPWR VPWR sky130_fd_sc_hd__decap_8
XFILLER_0_18_155 VGND VGND VPWR VPWR sky130_fd_sc_hd__fill_1
XFILLER_0_21_15 VGND VGND VPWR VPWR sky130_fd_sc_hd__fill_1
X_0590_ memory\[4\]\[2\] memory\[5\]\[2\] memory\[6\]\[2\] memory\[7\]\[2\] read_pointer\[0\]
+ _0237_ VGND VGND VPWR VPWR _0249_ sky130_fd_sc_hd__mux4_1
XFILLER_0_24_147 VGND VGND VPWR VPWR sky130_fd_sc_hd__fill_1
XFILLER_0_24_169 VGND VGND VPWR VPWR sky130_fd_sc_hd__decap_8
XFILLER_0_46_45 VGND VGND VPWR VPWR sky130_fd_sc_hd__decap_8
XFILLER_0_47_217 VGND VGND VPWR VPWR sky130_fd_sc_hd__decap_6
XFILLER_0_1_69 VPWR VGND VPWR VGND sky130_ef_sc_hd__decap_12
XFILLER_0_15_125 VPWR VGND VPWR VGND sky130_ef_sc_hd__decap_12
X_0857_ _0227_ _0412_ VGND VGND VPWR VPWR _0415_ sky130_fd_sc_hd__and2_1
X_0926_ clknet_4_4_0_clk _0030_ VGND VGND VPWR VPWR memory\[7\]\[5\] sky130_fd_sc_hd__dfxtp_1
Xhold27 memory\[5\]\[6\] VGND VGND VPWR VPWR net52 sky130_fd_sc_hd__dlygate4sd3_1
Xhold38 memory\[3\]\[5\] VGND VGND VPWR VPWR net63 sky130_fd_sc_hd__dlygate4sd3_1
Xhold16 memory\[11\]\[7\] VGND VGND VPWR VPWR net41 sky130_fd_sc_hd__dlygate4sd3_1
X_0788_ _0154_ net88 _0376_ VGND VGND VPWR VPWR _0377_ sky130_fd_sc_hd__mux2_1
XFILLER_0_30_139 VGND VGND VPWR VPWR sky130_fd_sc_hd__fill_1
Xhold49 memory\[12\]\[2\] VGND VGND VPWR VPWR net74 sky130_fd_sc_hd__dlygate4sd3_1
XFILLER_0_46_250 VGND VGND VPWR VPWR sky130_fd_sc_hd__fill_2
XFILLER_0_14_191 VGND VGND VPWR VPWR sky130_fd_sc_hd__decap_4
XFILLER_0_29_206 VGND VGND VPWR VPWR sky130_fd_sc_hd__decap_3
XFILLER_0_44_209 VGND VGND VPWR VPWR sky130_fd_sc_hd__decap_6
XFILLER_0_12_106 VPWR VGND VPWR VGND sky130_ef_sc_hd__decap_12
X_0711_ _0335_ VGND VGND VPWR VPWR _0077_ sky130_fd_sc_hd__clkbuf_1
X_0642_ net161 _0221_ _0291_ _0295_ _0236_ VGND VGND VPWR VPWR _0048_ sky130_fd_sc_hd__o221a_1
X_0573_ _0232_ _0233_ read_pointer\[2\] VGND VGND VPWR VPWR _0234_ sky130_fd_sc_hd__mux2_1
XFILLER_0_28_283 VPWR VGND VPWR VGND sky130_ef_sc_hd__decap_12
Xoutput17 net17 VGND VGND VPWR VPWR rd_data[2] sky130_fd_sc_hd__clkbuf_4
XFILLER_0_43_275 VGND VGND VPWR VPWR sky130_fd_sc_hd__decap_4
XFILLER_0_43_220 VGND VGND VPWR VPWR sky130_fd_sc_hd__decap_4
X_0909_ clknet_4_13_0_clk _0013_ VGND VGND VPWR VPWR memory\[2\]\[4\] sky130_fd_sc_hd__dfxtp_1
XPHY_101 VGND VGND VPWR VPWR sky130_fd_sc_hd__decap_3
XFILLER_0_34_253 VPWR VGND VPWR VGND sky130_ef_sc_hd__decap_12
XFILLER_0_34_297 VGND VGND VPWR VPWR sky130_fd_sc_hd__decap_8
XTAP_109 VGND VPWR sky130_fd_sc_hd__tapvpwrvgnd_1
XFILLER_0_27_47 VGND VGND VPWR VPWR sky130_fd_sc_hd__decap_3
XFILLER_0_27_69 VPWR VGND VPWR VGND sky130_ef_sc_hd__decap_12
XFILLER_0_43_46 VGND VGND VPWR VPWR sky130_fd_sc_hd__fill_1
XFILLER_0_43_35 VGND VGND VPWR VPWR sky130_fd_sc_hd__decap_3
XPHY_3 VGND VGND VPWR VPWR sky130_fd_sc_hd__decap_3
X_0625_ memory\[0\]\[6\] memory\[1\]\[6\] memory\[2\]\[6\] memory\[3\]\[6\] _0231_
+ _0237_ VGND VGND VPWR VPWR _0280_ sky130_fd_sc_hd__mux4_1
XFILLER_0_4_169 VGND VGND VPWR VPWR sky130_fd_sc_hd__decap_3
XFILLER_0_40_289 VPWR VGND VPWR VGND sky130_ef_sc_hd__decap_12
X_0556_ _0218_ VGND VGND VPWR VPWR _0039_ sky130_fd_sc_hd__clkbuf_1
X_0487_ _0154_ net155 _0179_ VGND VGND VPWR VPWR _0180_ sky130_fd_sc_hd__mux2_1
XFILLER_0_48_301 VGND VGND VPWR VPWR sky130_fd_sc_hd__decap_6
X_1039_ clknet_4_12_0_clk _0143_ VGND VGND VPWR VPWR read_pointer\[1\] sky130_fd_sc_hd__dfxtp_2
XFILLER_0_16_253 VPWR VGND VPWR VGND sky130_ef_sc_hd__decap_12
XFILLER_0_9_217 VGND VGND VPWR VPWR sky130_fd_sc_hd__fill_1
X_0608_ memory\[4\]\[4\] memory\[5\]\[4\] memory\[6\]\[4\] memory\[7\]\[4\] read_pointer\[0\]
+ read_pointer\[1\] VGND VGND VPWR VPWR _0265_ sky130_fd_sc_hd__mux4_1
Xhold124 memory\[14\]\[1\] VGND VGND VPWR VPWR net149 sky130_fd_sc_hd__dlygate4sd3_1
Xhold113 memory\[13\]\[5\] VGND VGND VPWR VPWR net138 sky130_fd_sc_hd__dlygate4sd3_1
XFILLER_0_0_161 VGND VGND VPWR VPWR sky130_fd_sc_hd__decap_6
XFILLER_0_13_223 VGND VGND VPWR VPWR sky130_fd_sc_hd__fill_1
Xhold135 net18 VGND VGND VPWR VPWR net160 sky130_fd_sc_hd__dlygate4sd3_1
Xhold102 memory\[13\]\[7\] VGND VGND VPWR VPWR net127 sky130_fd_sc_hd__dlygate4sd3_1
X_0539_ net94 _0174_ _0201_ VGND VGND VPWR VPWR _0209_ sky130_fd_sc_hd__mux2_1
XFILLER_0_36_304 VGND VGND VPWR VPWR sky130_fd_sc_hd__decap_3
XFILLER_0_5_3 VPWR VGND VPWR VGND sky130_ef_sc_hd__decap_12
X_0890_ _0440_ _0427_ _0428_ _0441_ VGND VGND VPWR VPWR _0442_ sky130_fd_sc_hd__a22oi_1
XFILLER_0_24_59 VGND VGND VPWR VPWR sky130_fd_sc_hd__fill_2
XFILLER_0_4_58 VPWR VGND VPWR VGND sky130_ef_sc_hd__decap_12
XFILLER_0_45_145 VGND VGND VPWR VPWR sky130_fd_sc_hd__decap_8
XFILLER_0_5_253 VPWR VGND VPWR VGND sky130_ef_sc_hd__decap_12
XTAP_292 VGND VPWR sky130_fd_sc_hd__tapvpwrvgnd_1
XTAP_281 VGND VPWR sky130_fd_sc_hd__tapvpwrvgnd_1
XTAP_270 VGND VPWR sky130_fd_sc_hd__tapvpwrvgnd_1
XFILLER_0_51_137 VGND VGND VPWR VPWR sky130_fd_sc_hd__decap_3
XFILLER_0_35_69 VPWR VGND VPWR VGND sky130_ef_sc_hd__decap_12
XFILLER_0_51_57 VPWR VGND VPWR VGND sky130_ef_sc_hd__decap_12
X_0942_ clknet_4_3_0_clk _0046_ VGND VGND VPWR VPWR net20 sky130_fd_sc_hd__dfxtp_1
X_0873_ _0156_ _0229_ VGND VGND VPWR VPWR _0427_ sky130_fd_sc_hd__nor2_4
XFILLER_0_27_145 VPWR VGND VPWR VGND sky130_ef_sc_hd__decap_12
XFILLER_0_2_289 VPWR VGND VPWR VGND sky130_ef_sc_hd__decap_12
XFILLER_0_18_167 VGND VGND VPWR VPWR sky130_fd_sc_hd__decap_6
XFILLER_0_33_126 VGND VGND VPWR VPWR sky130_fd_sc_hd__decap_3
XFILLER_0_49_281 VPWR VGND VPWR VGND sky130_ef_sc_hd__decap_12
XFILLER_0_32_181 VPWR VGND VPWR VGND sky130_ef_sc_hd__decap_12
XFILLER_0_46_79 VGND VGND VPWR VPWR sky130_fd_sc_hd__decap_4
XFILLER_0_1_15 VPWR VGND VPWR VGND sky130_ef_sc_hd__decap_12
X_0925_ clknet_4_13_0_clk _0029_ VGND VGND VPWR VPWR memory\[7\]\[4\] sky130_fd_sc_hd__dfxtp_1
XFILLER_0_15_137 VGND VGND VPWR VPWR sky130_fd_sc_hd__decap_4
X_0856_ _0414_ VGND VGND VPWR VPWR _0143_ sky130_fd_sc_hd__clkbuf_1
X_0787_ _0189_ _0199_ VGND VGND VPWR VPWR _0376_ sky130_fd_sc_hd__nand2_4
Xhold39 memory\[4\]\[1\] VGND VGND VPWR VPWR net64 sky130_fd_sc_hd__dlygate4sd3_1
Xhold28 memory\[9\]\[1\] VGND VGND VPWR VPWR net53 sky130_fd_sc_hd__dlygate4sd3_1
Xhold17 memory\[8\]\[4\] VGND VGND VPWR VPWR net42 sky130_fd_sc_hd__dlygate4sd3_1
XFILLER_0_16_27 VGND VGND VPWR VPWR sky130_fd_sc_hd__fill_1
XFILLER_0_16_49 VGND VGND VPWR VPWR sky130_fd_sc_hd__fill_2
XFILLER_0_32_15 VPWR VGND VPWR VGND sky130_ef_sc_hd__decap_12
XFILLER_0_32_37 VGND VGND VPWR VPWR sky130_fd_sc_hd__decap_6
XFILLER_0_32_59 VGND VGND VPWR VPWR sky130_fd_sc_hd__fill_1
XFILLER_0_12_118 VGND VGND VPWR VPWR sky130_fd_sc_hd__decap_8
X_0641_ _0222_ _0294_ _0229_ VGND VGND VPWR VPWR _0295_ sky130_fd_sc_hd__a21o_1
X_0710_ net35 net7 _0330_ VGND VGND VPWR VPWR _0335_ sky130_fd_sc_hd__mux2_1
X_0572_ memory\[4\]\[0\] memory\[5\]\[0\] memory\[6\]\[0\] memory\[7\]\[0\] _0231_
+ _0224_ VGND VGND VPWR VPWR _0233_ sky130_fd_sc_hd__mux4_1
XFILLER_0_7_167 VGND VGND VPWR VPWR sky130_fd_sc_hd__fill_1
XFILLER_0_7_134 VPWR VGND VPWR VGND sky130_ef_sc_hd__decap_12
XFILLER_0_28_295 VPWR VGND VPWR VGND sky130_ef_sc_hd__decap_12
X_0908_ clknet_4_7_0_clk _0012_ VGND VGND VPWR VPWR memory\[2\]\[3\] sky130_fd_sc_hd__dfxtp_1
Xoutput18 net18 VGND VGND VPWR VPWR rd_data[3] sky130_fd_sc_hd__clkbuf_4
XFILLER_0_11_151 VGND VGND VPWR VPWR sky130_fd_sc_hd__fill_1
X_0839_ net11 _0155_ net13 VGND VGND VPWR VPWR _0404_ sky130_fd_sc_hd__and3_1
XPHY_102 VGND VGND VPWR VPWR sky130_fd_sc_hd__decap_3
XFILLER_0_34_265 VPWR VGND VPWR VGND sky130_ef_sc_hd__decap_12
XFILLER_0_27_15 VPWR VGND VPWR VGND sky130_ef_sc_hd__decap_12
XPHY_4 VGND VGND VPWR VPWR sky130_fd_sc_hd__decap_3
X_0624_ net140 _0221_ _0275_ _0279_ _0236_ VGND VGND VPWR VPWR _0046_ sky130_fd_sc_hd__o221a_1
X_0555_ _0172_ net144 _0211_ VGND VGND VPWR VPWR _0218_ sky130_fd_sc_hd__mux2_1
X_0486_ _0178_ VGND VGND VPWR VPWR _0179_ sky130_fd_sc_hd__clkbuf_4
XFILLER_0_17_81 VPWR VGND VPWR VGND sky130_ef_sc_hd__decap_12
X_1038_ clknet_4_11_0_clk _0142_ VGND VGND VPWR VPWR read_pointer\[0\] sky130_fd_sc_hd__dfxtp_4
XFILLER_0_16_276 VPWR VGND VPWR VGND sky130_ef_sc_hd__decap_12
XFILLER_0_1_129 VGND VGND VPWR VPWR sky130_fd_sc_hd__fill_1
XFILLER_0_45_305 VGND VGND VPWR VPWR sky130_fd_sc_hd__fill_2
Xhold125 memory\[1\]\[3\] VGND VGND VPWR VPWR net150 sky130_fd_sc_hd__dlygate4sd3_1
X_0607_ memory\[0\]\[4\] memory\[1\]\[4\] memory\[2\]\[4\] memory\[3\]\[4\] _0231_
+ _0237_ VGND VGND VPWR VPWR _0264_ sky130_fd_sc_hd__mux4_1
X_0538_ _0208_ VGND VGND VPWR VPWR _0031_ sky130_fd_sc_hd__clkbuf_1
Xhold114 memory\[15\]\[6\] VGND VGND VPWR VPWR net139 sky130_fd_sc_hd__dlygate4sd3_1
Xhold103 memory\[8\]\[5\] VGND VGND VPWR VPWR net128 sky130_fd_sc_hd__dlygate4sd3_1
XFILLER_0_13_279 VGND VGND VPWR VPWR sky130_fd_sc_hd__fill_1
Xhold136 net22 VGND VGND VPWR VPWR net161 sky130_fd_sc_hd__dlygate4sd3_1
X_0469_ _0167_ VGND VGND VPWR VPWR _0003_ sky130_fd_sc_hd__clkbuf_1
XFILLER_0_8_251 VGND VGND VPWR VPWR sky130_fd_sc_hd__fill_1
XFILLER_0_24_27 VGND VGND VPWR VPWR sky130_fd_sc_hd__fill_1
XFILLER_0_40_15 VPWR VGND VPWR VGND sky130_ef_sc_hd__decap_12
XFILLER_0_27_305 VGND VGND VPWR VPWR sky130_fd_sc_hd__fill_2
XFILLER_0_49_57 VPWR VGND VPWR VGND sky130_ef_sc_hd__decap_12
XFILLER_0_4_15 VPWR VGND VPWR VGND sky130_ef_sc_hd__decap_12
XFILLER_0_5_265 VPWR VGND VPWR VGND sky130_ef_sc_hd__decap_12
XTAP_293 VGND VPWR sky130_fd_sc_hd__tapvpwrvgnd_1
XTAP_282 VGND VPWR sky130_fd_sc_hd__tapvpwrvgnd_1
XTAP_271 VGND VPWR sky130_fd_sc_hd__tapvpwrvgnd_1
XTAP_260 VGND VPWR sky130_fd_sc_hd__tapvpwrvgnd_1
XFILLER_0_51_149 VGND VGND VPWR VPWR sky130_fd_sc_hd__fill_1
XFILLER_0_35_15 VGND VGND VPWR VPWR sky130_fd_sc_hd__decap_4
XFILLER_0_51_69 VPWR VGND VPWR VGND sky130_ef_sc_hd__decap_12
X_0941_ clknet_4_9_0_clk _0045_ VGND VGND VPWR VPWR net19 sky130_fd_sc_hd__dfxtp_1
XFILLER_0_2_213 VPWR VGND VPWR VGND sky130_ef_sc_hd__decap_12
XFILLER_0_27_157 VGND VGND VPWR VPWR sky130_fd_sc_hd__decap_8
X_0872_ _0421_ _0425_ _0426_ VGND VGND VPWR VPWR _0147_ sky130_fd_sc_hd__o21a_1
XFILLER_0_33_138 VGND VGND VPWR VPWR sky130_fd_sc_hd__decap_8
XFILLER_0_49_293 VPWR VGND VPWR VGND sky130_ef_sc_hd__decap_12
XFILLER_0_32_193 VGND VGND VPWR VPWR sky130_fd_sc_hd__decap_3
XFILLER_0_1_27 VPWR VGND VPWR VGND sky130_ef_sc_hd__decap_12
X_0924_ clknet_4_7_0_clk _0028_ VGND VGND VPWR VPWR memory\[7\]\[3\] sky130_fd_sc_hd__dfxtp_1
XFILLER_0_7_305 VGND VGND VPWR VPWR sky130_fd_sc_hd__fill_2
X_0786_ _0375_ VGND VGND VPWR VPWR _0112_ sky130_fd_sc_hd__clkbuf_1
X_0855_ _0412_ _0155_ _0413_ VGND VGND VPWR VPWR _0414_ sky130_fd_sc_hd__and3b_1
XFILLER_0_39_3 VPWR VGND VPWR VGND sky130_ef_sc_hd__decap_12
Xhold29 memory\[11\]\[1\] VGND VGND VPWR VPWR net54 sky130_fd_sc_hd__dlygate4sd3_1
Xhold18 memory\[7\]\[5\] VGND VGND VPWR VPWR net43 sky130_fd_sc_hd__dlygate4sd3_1
XFILLER_0_32_27 VGND VGND VPWR VPWR sky130_fd_sc_hd__fill_1
X_0571_ memory\[0\]\[0\] memory\[1\]\[0\] memory\[2\]\[0\] memory\[3\]\[0\] _0231_
+ _0224_ VGND VGND VPWR VPWR _0232_ sky130_fd_sc_hd__mux4_1
X_0640_ _0292_ _0293_ _0227_ VGND VGND VPWR VPWR _0294_ sky130_fd_sc_hd__mux2_1
X_0907_ clknet_4_15_0_clk _0011_ VGND VGND VPWR VPWR memory\[2\]\[2\] sky130_fd_sc_hd__dfxtp_1
XFILLER_0_7_146 VGND VGND VPWR VPWR sky130_fd_sc_hd__decap_8
XFILLER_0_7_113 VGND VGND VPWR VPWR sky130_fd_sc_hd__decap_8
XFILLER_0_22_82 VGND VGND VPWR VPWR sky130_fd_sc_hd__fill_2
X_0769_ _0366_ VGND VGND VPWR VPWR _0104_ sky130_fd_sc_hd__clkbuf_1
X_0838_ _0403_ VGND VGND VPWR VPWR _0136_ sky130_fd_sc_hd__clkbuf_1
Xoutput19 net19 VGND VGND VPWR VPWR rd_data[4] sky130_fd_sc_hd__clkbuf_4
XPHY_103 VGND VGND VPWR VPWR sky130_fd_sc_hd__decap_3
XFILLER_0_34_277 VGND VGND VPWR VPWR sky130_fd_sc_hd__decap_4
XFILLER_0_27_27 VPWR VGND VPWR VGND sky130_ef_sc_hd__decap_12
XFILLER_0_43_15 VGND VGND VPWR VPWR sky130_fd_sc_hd__decap_8
XPHY_5 VGND VGND VPWR VPWR sky130_fd_sc_hd__decap_3
XFILLER_0_4_149 VPWR VGND VPWR VGND sky130_ef_sc_hd__decap_12
XFILLER_0_7_15 VGND VGND VPWR VPWR sky130_fd_sc_hd__decap_3
X_0623_ _0222_ _0278_ _0229_ VGND VGND VPWR VPWR _0279_ sky130_fd_sc_hd__a21o_1
X_0554_ _0217_ VGND VGND VPWR VPWR _0038_ sky130_fd_sc_hd__clkbuf_1
X_0485_ write_pointer\[3\] write_pointer\[2\] _0177_ VGND VGND VPWR VPWR _0178_ sky130_fd_sc_hd__or3b_1
X_1037_ clknet_4_14_0_clk _0141_ VGND VGND VPWR VPWR write_pointer\[3\] sky130_fd_sc_hd__dfxtp_1
XFILLER_0_17_93 VGND VGND VPWR VPWR sky130_fd_sc_hd__decap_8
XFILLER_0_16_288 VPWR VGND VPWR VGND sky130_ef_sc_hd__decap_12
XFILLER_0_31_236 VGND VGND VPWR VPWR sky130_fd_sc_hd__decap_6
XFILLER_0_38_15 VGND VGND VPWR VPWR sky130_fd_sc_hd__decap_3
XFILLER_0_22_269 VPWR VGND VPWR VGND sky130_ef_sc_hd__decap_12
Xhold126 memory\[5\]\[3\] VGND VGND VPWR VPWR net151 sky130_fd_sc_hd__dlygate4sd3_1
XFILLER_0_13_225 VGND VGND VPWR VPWR sky130_fd_sc_hd__decap_6
XFILLER_0_13_247 VPWR VGND VPWR VGND sky130_ef_sc_hd__decap_12
Xhold104 memory\[11\]\[6\] VGND VGND VPWR VPWR net129 sky130_fd_sc_hd__dlygate4sd3_1
Xhold115 net20 VGND VGND VPWR VPWR net140 sky130_fd_sc_hd__dlygate4sd3_1
X_0537_ net77 _0172_ _0201_ VGND VGND VPWR VPWR _0208_ sky130_fd_sc_hd__mux2_1
XFILLER_0_0_141 VPWR VGND VPWR VGND sky130_ef_sc_hd__decap_12
Xhold137 net21 VGND VGND VPWR VPWR net162 sky130_fd_sc_hd__dlygate4sd3_1
X_0606_ net160 _0221_ _0259_ _0263_ _0236_ VGND VGND VPWR VPWR _0044_ sky130_fd_sc_hd__o221a_1
XFILLER_0_21_3 VGND VGND VPWR VPWR sky130_fd_sc_hd__decap_8
X_0468_ net119 _0166_ _0160_ VGND VGND VPWR VPWR _0167_ sky130_fd_sc_hd__mux2_1
XFILLER_0_48_188 VGND VGND VPWR VPWR sky130_fd_sc_hd__decap_4
XFILLER_0_8_80 VGND VGND VPWR VPWR sky130_fd_sc_hd__fill_1
XFILLER_0_39_177 VGND VGND VPWR VPWR sky130_fd_sc_hd__decap_6
XFILLER_0_39_166 VGND VGND VPWR VPWR sky130_fd_sc_hd__fill_2
XFILLER_0_40_27 VGND VGND VPWR VPWR sky130_fd_sc_hd__fill_1
XFILLER_0_49_69 VGND VGND VPWR VPWR sky130_fd_sc_hd__fill_1
XFILLER_0_4_27 VGND VGND VPWR VPWR sky130_fd_sc_hd__fill_1
XFILLER_0_45_169 VPWR VGND VPWR VGND sky130_ef_sc_hd__decap_12
XFILLER_0_18_306 VGND VGND VPWR VPWR sky130_fd_sc_hd__fill_1
XFILLER_0_5_277 VGND VGND VPWR VPWR sky130_fd_sc_hd__decap_3
XFILLER_0_30_82 VGND VGND VPWR VPWR sky130_fd_sc_hd__fill_2
XTAP_294 VGND VPWR sky130_fd_sc_hd__tapvpwrvgnd_1
XTAP_283 VGND VPWR sky130_fd_sc_hd__tapvpwrvgnd_1
XTAP_272 VGND VPWR sky130_fd_sc_hd__tapvpwrvgnd_1
XTAP_250 VGND VPWR sky130_fd_sc_hd__tapvpwrvgnd_1
XTAP_261 VGND VPWR sky130_fd_sc_hd__tapvpwrvgnd_1
XFILLER_0_51_37 VGND VGND VPWR VPWR sky130_fd_sc_hd__fill_1
X_0940_ clknet_4_3_0_clk _0044_ VGND VGND VPWR VPWR net18 sky130_fd_sc_hd__dfxtp_1
XFILLER_0_50_194 VGND VGND VPWR VPWR sky130_fd_sc_hd__fill_2
XFILLER_0_2_225 VPWR VGND VPWR VGND sky130_ef_sc_hd__decap_12
X_0871_ _0421_ _0425_ _0296_ VGND VGND VPWR VPWR _0426_ sky130_fd_sc_hd__a21oi_1
XFILLER_0_33_117 VGND VGND VPWR VPWR sky130_fd_sc_hd__fill_1
XFILLER_0_33_106 VGND VGND VPWR VPWR sky130_fd_sc_hd__decap_6
XFILLER_0_18_147 VGND VGND VPWR VPWR sky130_fd_sc_hd__decap_8
XFILLER_0_49_261 VPWR VGND VPWR VGND sky130_ef_sc_hd__decap_12
XFILLER_0_24_139 VGND VGND VPWR VPWR sky130_fd_sc_hd__fill_1
XFILLER_0_1_39 VPWR VGND VPWR VGND sky130_ef_sc_hd__decap_12
X_0923_ clknet_4_12_0_clk _0027_ VGND VGND VPWR VPWR memory\[7\]\[2\] sky130_fd_sc_hd__dfxtp_1
X_0854_ _0242_ _0220_ _0243_ VGND VGND VPWR VPWR _0413_ sky130_fd_sc_hd__a21o_1
X_0785_ net59 net10 _0367_ VGND VGND VPWR VPWR _0375_ sky130_fd_sc_hd__mux2_1
XFILLER_0_11_84 VPWR VGND VPWR VGND sky130_ef_sc_hd__decap_12
XFILLER_0_36_81 VGND VGND VPWR VPWR sky130_fd_sc_hd__decap_3
Xhold19 memory\[3\]\[2\] VGND VGND VPWR VPWR net44 sky130_fd_sc_hd__dlygate4sd3_1
XFILLER_0_38_209 VGND VGND VPWR VPWR sky130_fd_sc_hd__fill_2
XFILLER_0_46_253 VPWR VGND VPWR VGND sky130_ef_sc_hd__decap_12
XFILLER_0_16_29 VPWR VGND VPWR VGND sky130_ef_sc_hd__decap_12
X_0570_ read_pointer\[0\] VGND VGND VPWR VPWR _0231_ sky130_fd_sc_hd__buf_4
XFILLER_0_20_197 VPWR VGND VPWR VGND sky130_ef_sc_hd__decap_12
X_0906_ clknet_4_13_0_clk _0010_ VGND VGND VPWR VPWR memory\[2\]\[1\] sky130_fd_sc_hd__dfxtp_1
X_0837_ _0174_ net147 _0395_ VGND VGND VPWR VPWR _0403_ sky130_fd_sc_hd__mux2_1
XFILLER_0_7_169 VGND VGND VPWR VPWR sky130_fd_sc_hd__decap_6
XFILLER_0_28_253 VPWR VGND VPWR VGND sky130_ef_sc_hd__decap_12
X_0768_ net84 net10 _0358_ VGND VGND VPWR VPWR _0366_ sky130_fd_sc_hd__mux2_1
X_0699_ write_pointer\[2\] write_pointer\[3\] VGND VGND VPWR VPWR _0328_ sky130_fd_sc_hd__and2b_2
XFILLER_0_2_82 VGND VGND VPWR VPWR sky130_fd_sc_hd__fill_2
XFILLER_0_19_242 VPWR VGND VPWR VGND sky130_ef_sc_hd__decap_12
XFILLER_0_19_275 VGND VGND VPWR VPWR sky130_fd_sc_hd__decap_4
XFILLER_0_27_39 VGND VGND VPWR VPWR sky130_fd_sc_hd__decap_8
XPHY_6 VGND VGND VPWR VPWR sky130_fd_sc_hd__decap_3
X_0622_ _0276_ _0277_ _0227_ VGND VGND VPWR VPWR _0278_ sky130_fd_sc_hd__mux2_1
X_0484_ write_pointer\[0\] net2 _0156_ write_pointer\[1\] VGND VGND VPWR VPWR _0177_
+ sky130_fd_sc_hd__and4b_4
X_0553_ _0170_ net39 _0211_ VGND VGND VPWR VPWR _0217_ sky130_fd_sc_hd__mux2_1
X_1036_ clknet_4_14_0_clk _0140_ VGND VGND VPWR VPWR write_pointer\[2\] sky130_fd_sc_hd__dfxtp_1
XFILLER_0_38_27 VGND VGND VPWR VPWR sky130_fd_sc_hd__fill_1
XFILLER_0_9_209 VGND VGND VPWR VPWR sky130_fd_sc_hd__decap_8
Xhold105 memory\[6\]\[3\] VGND VGND VPWR VPWR net130 sky130_fd_sc_hd__dlygate4sd3_1
Xhold127 memory\[6\]\[4\] VGND VGND VPWR VPWR net152 sky130_fd_sc_hd__dlygate4sd3_1
Xhold116 memory\[14\]\[2\] VGND VGND VPWR VPWR net141 sky130_fd_sc_hd__dlygate4sd3_1
XFILLER_0_13_259 VPWR VGND VPWR VGND sky130_ef_sc_hd__decap_12
Xhold138 net17 VGND VGND VPWR VPWR net163 sky130_fd_sc_hd__dlygate4sd3_1
X_0467_ net6 VGND VGND VPWR VPWR _0166_ sky130_fd_sc_hd__buf_2
XFILLER_0_0_153 VGND VGND VPWR VPWR sky130_fd_sc_hd__decap_4
XFILLER_0_0_197 VPWR VGND VPWR VGND sky130_ef_sc_hd__decap_12
X_0605_ _0222_ _0262_ _0229_ VGND VGND VPWR VPWR _0263_ sky130_fd_sc_hd__a21o_1
XFILLER_0_21_292 VPWR VGND VPWR VGND sky130_ef_sc_hd__decap_12
XFILLER_0_28_82 VGND VGND VPWR VPWR sky130_fd_sc_hd__fill_2
X_0536_ _0207_ VGND VGND VPWR VPWR _0030_ sky130_fd_sc_hd__clkbuf_1
X_1019_ clknet_4_10_0_clk _0123_ VGND VGND VPWR VPWR memory\[8\]\[2\] sky130_fd_sc_hd__dfxtp_1
XFILLER_0_14_3 VPWR VGND VPWR VGND sky130_ef_sc_hd__decap_12
XFILLER_0_48_178 VGND VGND VPWR VPWR sky130_fd_sc_hd__fill_1
XFILLER_0_8_220 VGND VGND VPWR VPWR sky130_fd_sc_hd__decap_4
XFILLER_0_8_253 VPWR VGND VPWR VGND sky130_ef_sc_hd__decap_12
XFILLER_0_49_15 VPWR VGND VPWR VGND sky130_ef_sc_hd__decap_12
XFILLER_0_10_207 VPWR VGND VPWR VGND sky130_ef_sc_hd__decap_12
XFILLER_0_5_223 VGND VGND VPWR VPWR sky130_fd_sc_hd__fill_1
XFILLER_0_14_51 VGND VGND VPWR VPWR sky130_fd_sc_hd__decap_4
XFILLER_0_30_72 VGND VGND VPWR VPWR sky130_fd_sc_hd__fill_1
XTAP_295 VGND VPWR sky130_fd_sc_hd__tapvpwrvgnd_1
XTAP_284 VGND VPWR sky130_fd_sc_hd__tapvpwrvgnd_1
XTAP_273 VGND VPWR sky130_fd_sc_hd__tapvpwrvgnd_1
X_0519_ _0197_ VGND VGND VPWR VPWR _0023_ sky130_fd_sc_hd__clkbuf_1
XTAP_240 VGND VPWR sky130_fd_sc_hd__tapvpwrvgnd_1
XTAP_251 VGND VPWR sky130_fd_sc_hd__tapvpwrvgnd_1
XTAP_262 VGND VPWR sky130_fd_sc_hd__tapvpwrvgnd_1
XFILLER_0_36_159 VGND VGND VPWR VPWR sky130_fd_sc_hd__fill_1
XFILLER_0_3_3 VPWR VGND VPWR VGND sky130_ef_sc_hd__decap_12
XFILLER_0_51_27 VGND VGND VPWR VPWR sky130_fd_sc_hd__fill_1
X_0870_ _0423_ _0424_ VGND VGND VPWR VPWR _0425_ sky130_fd_sc_hd__or2b_1
XFILLER_0_2_237 VPWR VGND VPWR VGND sky130_ef_sc_hd__decap_12
XFILLER_0_25_50 VGND VGND VPWR VPWR sky130_fd_sc_hd__decap_6
X_0999_ clknet_4_4_0_clk _0103_ VGND VGND VPWR VPWR memory\[4\]\[6\] sky130_fd_sc_hd__dfxtp_1
XFILLER_0_5_71 VPWR VGND VPWR VGND sky130_ef_sc_hd__decap_12
XFILLER_0_1_281 VPWR VGND VPWR VGND sky130_ef_sc_hd__decap_12
XFILLER_0_49_273 VGND VGND VPWR VPWR sky130_fd_sc_hd__decap_6
XFILLER_0_46_27 VGND VGND VPWR VPWR sky130_fd_sc_hd__fill_1
X_0922_ clknet_4_7_0_clk _0026_ VGND VGND VPWR VPWR memory\[7\]\[1\] sky130_fd_sc_hd__dfxtp_1
X_0853_ _0243_ _0242_ _0220_ VGND VGND VPWR VPWR _0412_ sky130_fd_sc_hd__and3_1
X_0784_ _0374_ VGND VGND VPWR VPWR _0111_ sky130_fd_sc_hd__clkbuf_1
XFILLER_0_11_96 VPWR VGND VPWR VGND sky130_ef_sc_hd__decap_12
XFILLER_0_36_71 VGND VGND VPWR VPWR sky130_fd_sc_hd__fill_1
Xinput1 rd_en VGND VGND VPWR VPWR net1 sky130_fd_sc_hd__buf_2
XFILLER_0_46_265 VPWR VGND VPWR VGND sky130_ef_sc_hd__decap_12
XFILLER_0_14_173 VGND VGND VPWR VPWR sky130_fd_sc_hd__decap_3
XFILLER_0_14_195 VGND VGND VPWR VPWR sky130_fd_sc_hd__fill_1
XFILLER_0_7_104 VGND VGND VPWR VPWR sky130_fd_sc_hd__decap_8
XFILLER_0_28_265 VGND VGND VPWR VPWR sky130_fd_sc_hd__decap_3
XFILLER_0_43_279 VGND VGND VPWR VPWR sky130_fd_sc_hd__fill_1
X_0836_ _0402_ VGND VGND VPWR VPWR _0135_ sky130_fd_sc_hd__clkbuf_1
X_0767_ _0365_ VGND VGND VPWR VPWR _0103_ sky130_fd_sc_hd__clkbuf_1
X_0905_ clknet_4_6_0_clk _0009_ VGND VGND VPWR VPWR memory\[2\]\[0\] sky130_fd_sc_hd__dfxtp_1
XFILLER_0_22_73 VGND VGND VPWR VPWR sky130_fd_sc_hd__fill_1
XFILLER_0_44_3 VPWR VGND VPWR VGND sky130_ef_sc_hd__decap_12
X_0698_ _0327_ VGND VGND VPWR VPWR _0072_ sky130_fd_sc_hd__clkbuf_1
XFILLER_0_34_213 VGND VGND VPWR VPWR sky130_fd_sc_hd__decap_8
XPHY_7 VGND VGND VPWR VPWR sky130_fd_sc_hd__decap_3
X_0621_ memory\[12\]\[5\] memory\[13\]\[5\] memory\[14\]\[5\] memory\[15\]\[5\] _0223_
+ _0224_ VGND VGND VPWR VPWR _0277_ sky130_fd_sc_hd__mux4_1
XFILLER_0_4_118 VGND VGND VPWR VPWR sky130_fd_sc_hd__fill_1
XFILLER_0_25_279 VGND VGND VPWR VPWR sky130_fd_sc_hd__fill_1
X_0552_ _0216_ VGND VGND VPWR VPWR _0037_ sky130_fd_sc_hd__clkbuf_1
X_0483_ _0176_ VGND VGND VPWR VPWR _0008_ sky130_fd_sc_hd__clkbuf_1
X_1035_ clknet_4_14_0_clk _0139_ VGND VGND VPWR VPWR write_pointer\[1\] sky130_fd_sc_hd__dfxtp_1
XFILLER_0_33_83 VGND VGND VPWR VPWR sky130_fd_sc_hd__decap_6
XFILLER_0_3_162 VGND VGND VPWR VPWR sky130_fd_sc_hd__decap_6
X_0819_ _0393_ VGND VGND VPWR VPWR _0127_ sky130_fd_sc_hd__clkbuf_1
XFILLER_0_31_216 VGND VGND VPWR VPWR sky130_fd_sc_hd__decap_3
XFILLER_0_39_305 VGND VGND VPWR VPWR sky130_fd_sc_hd__fill_2
XFILLER_0_22_238 VPWR VGND VPWR VGND sky130_ef_sc_hd__decap_12
XFILLER_0_38_39 VPWR VGND VPWR VGND sky130_ef_sc_hd__decap_12
Xhold128 memory\[2\]\[7\] VGND VGND VPWR VPWR net153 sky130_fd_sc_hd__dlygate4sd3_1
Xhold106 memory\[9\]\[2\] VGND VGND VPWR VPWR net131 sky130_fd_sc_hd__dlygate4sd3_1
XFILLER_0_21_260 VPWR VGND VPWR VGND sky130_ef_sc_hd__decap_12
X_0604_ _0260_ _0261_ _0227_ VGND VGND VPWR VPWR _0262_ sky130_fd_sc_hd__mux2_1
Xhold117 memory\[9\]\[7\] VGND VGND VPWR VPWR net142 sky130_fd_sc_hd__dlygate4sd3_1
Xhold139 data_count\[0\] VGND VGND VPWR VPWR net164 sky130_fd_sc_hd__dlygate4sd3_1
X_0466_ _0165_ VGND VGND VPWR VPWR _0002_ sky130_fd_sc_hd__clkbuf_1
X_0535_ net43 _0170_ _0201_ VGND VGND VPWR VPWR _0207_ sky130_fd_sc_hd__mux2_1
XFILLER_0_48_135 VGND VGND VPWR VPWR sky130_fd_sc_hd__decap_4
XFILLER_0_48_113 VGND VGND VPWR VPWR sky130_fd_sc_hd__fill_1
X_1018_ clknet_4_8_0_clk _0122_ VGND VGND VPWR VPWR memory\[8\]\[1\] sky130_fd_sc_hd__dfxtp_1
XFILLER_0_8_265 VPWR VGND VPWR VGND sky130_ef_sc_hd__decap_12
XFILLER_0_39_113 VPWR VGND VPWR VGND sky130_ef_sc_hd__decap_12
XFILLER_0_40_29 VPWR VGND VPWR VGND sky130_ef_sc_hd__decap_12
XFILLER_0_49_27 VPWR VGND VPWR VGND sky130_ef_sc_hd__decap_12
XFILLER_0_10_219 VGND VGND VPWR VPWR sky130_fd_sc_hd__decap_6
XFILLER_0_4_29 VGND VGND VPWR VPWR sky130_fd_sc_hd__decap_4
XFILLER_0_14_85 VGND VGND VPWR VPWR sky130_fd_sc_hd__decap_3
X_0518_ _0172_ net114 _0190_ VGND VGND VPWR VPWR _0197_ sky130_fd_sc_hd__mux2_1
XTAP_230 VGND VPWR sky130_fd_sc_hd__tapvpwrvgnd_1
XTAP_241 VGND VPWR sky130_fd_sc_hd__tapvpwrvgnd_1
XTAP_296 VGND VPWR sky130_fd_sc_hd__tapvpwrvgnd_1
XTAP_285 VGND VPWR sky130_fd_sc_hd__tapvpwrvgnd_1
XTAP_274 VGND VPWR sky130_fd_sc_hd__tapvpwrvgnd_1
X_0449_ data_count\[3\] data_count\[2\] data_count\[1\] data_count\[0\] VGND VGND
+ VPWR VPWR _0152_ sky130_fd_sc_hd__nor4_1
XTAP_252 VGND VPWR sky130_fd_sc_hd__tapvpwrvgnd_1
XTAP_263 VGND VPWR sky130_fd_sc_hd__tapvpwrvgnd_1
XFILLER_0_50_185 VGND VGND VPWR VPWR sky130_fd_sc_hd__fill_1
XFILLER_0_50_174 VGND VGND VPWR VPWR sky130_fd_sc_hd__decap_8
XFILLER_0_50_141 VPWR VGND VPWR VGND sky130_ef_sc_hd__decap_12
XFILLER_0_2_249 VGND VGND VPWR VPWR sky130_fd_sc_hd__decap_3
XFILLER_0_18_116 VPWR VGND VPWR VGND sky130_ef_sc_hd__decap_12
X_0998_ clknet_4_4_0_clk _0102_ VGND VGND VPWR VPWR memory\[4\]\[5\] sky130_fd_sc_hd__dfxtp_1
XFILLER_0_5_83 VPWR VGND VPWR VGND sky130_ef_sc_hd__decap_12
XFILLER_0_1_293 VPWR VGND VPWR VGND sky130_ef_sc_hd__decap_12
XFILLER_0_20_303 VGND VGND VPWR VPWR sky130_fd_sc_hd__decap_4
X_0921_ clknet_4_6_0_clk _0025_ VGND VGND VPWR VPWR memory\[7\]\[0\] sky130_fd_sc_hd__dfxtp_1
X_0783_ net81 net9 _0367_ VGND VGND VPWR VPWR _0374_ sky130_fd_sc_hd__mux2_1
XFILLER_0_11_75 VGND VGND VPWR VPWR sky130_fd_sc_hd__fill_1
X_0852_ _0242_ _0221_ _0411_ VGND VGND VPWR VPWR _0142_ sky130_fd_sc_hd__o21a_1
XFILLER_0_46_7 VPWR VGND VPWR VGND sky130_ef_sc_hd__decap_12
XFILLER_0_23_196 VGND VGND VPWR VPWR sky130_fd_sc_hd__decap_8
Xinput2 rst_n VGND VGND VPWR VPWR net2 sky130_fd_sc_hd__clkbuf_2
XFILLER_0_46_277 VPWR VGND VPWR VGND sky130_ef_sc_hd__decap_12
XFILLER_0_14_141 VPWR VGND VPWR VGND sky130_ef_sc_hd__decap_12
X_0904_ clknet_4_10_0_clk _0008_ VGND VGND VPWR VPWR net23 sky130_fd_sc_hd__dfxtp_1
XFILLER_0_22_41 VPWR VGND VPWR VGND sky130_ef_sc_hd__decap_12
XFILLER_0_22_85 VPWR VGND VPWR VGND sky130_ef_sc_hd__decap_12
XFILLER_0_28_211 VGND VGND VPWR VPWR sky130_fd_sc_hd__fill_1
XFILLER_0_28_244 VGND VGND VPWR VPWR sky130_fd_sc_hd__decap_8
X_0835_ _0172_ net137 _0395_ VGND VGND VPWR VPWR _0402_ sky130_fd_sc_hd__mux2_1
X_0766_ net91 net9 _0358_ VGND VGND VPWR VPWR _0365_ sky130_fd_sc_hd__mux2_1
X_0697_ _0174_ net157 _0319_ VGND VGND VPWR VPWR _0327_ sky130_fd_sc_hd__mux2_1
XFILLER_0_37_3 VGND VGND VPWR VPWR sky130_fd_sc_hd__decap_8
XFILLER_0_2_62 VPWR VGND VPWR VGND sky130_ef_sc_hd__decap_12
XFILLER_0_34_225 VGND VGND VPWR VPWR sky130_fd_sc_hd__decap_8
XFILLER_0_6_182 VGND VGND VPWR VPWR sky130_fd_sc_hd__fill_1
XPHY_8 VGND VGND VPWR VPWR sky130_fd_sc_hd__decap_3
XFILLER_0_25_225 VGND VGND VPWR VPWR sky130_fd_sc_hd__decap_6
X_0551_ _0168_ net116 _0211_ VGND VGND VPWR VPWR _0216_ sky130_fd_sc_hd__mux2_1
XFILLER_0_40_206 VPWR VGND VPWR VGND sky130_ef_sc_hd__decap_12
X_0620_ memory\[8\]\[5\] memory\[9\]\[5\] memory\[10\]\[5\] memory\[11\]\[5\] _0242_
+ _0243_ VGND VGND VPWR VPWR _0276_ sky130_fd_sc_hd__mux4_1
XFILLER_0_25_247 VPWR VGND VPWR VGND sky130_ef_sc_hd__decap_12
X_0482_ net1 _0155_ net12 VGND VGND VPWR VPWR _0176_ sky130_fd_sc_hd__and3_1
XFILLER_0_33_51 VGND VGND VPWR VPWR sky130_fd_sc_hd__decap_4
X_1034_ clknet_4_11_0_clk _0138_ VGND VGND VPWR VPWR write_pointer\[0\] sky130_fd_sc_hd__dfxtp_1
X_0749_ _0355_ VGND VGND VPWR VPWR _0095_ sky130_fd_sc_hd__clkbuf_1
X_0818_ net109 net9 _0386_ VGND VGND VPWR VPWR _0393_ sky130_fd_sc_hd__mux2_1
XFILLER_0_38_29 VGND VGND VPWR VPWR sky130_fd_sc_hd__fill_2
Xhold107 memory\[6\]\[1\] VGND VGND VPWR VPWR net132 sky130_fd_sc_hd__dlygate4sd3_1
X_0534_ _0206_ VGND VGND VPWR VPWR _0029_ sky130_fd_sc_hd__clkbuf_1
XFILLER_0_0_111 VGND VGND VPWR VPWR sky130_fd_sc_hd__fill_1
Xhold129 memory\[14\]\[4\] VGND VGND VPWR VPWR net154 sky130_fd_sc_hd__dlygate4sd3_1
XFILLER_0_21_272 VGND VGND VPWR VPWR sky130_fd_sc_hd__decap_8
X_0603_ memory\[12\]\[3\] memory\[13\]\[3\] memory\[14\]\[3\] memory\[15\]\[3\] _0223_
+ _0224_ VGND VGND VPWR VPWR _0261_ sky130_fd_sc_hd__mux4_1
Xhold118 net19 VGND VGND VPWR VPWR net143 sky130_fd_sc_hd__dlygate4sd3_1
X_0465_ net113 _0164_ _0160_ VGND VGND VPWR VPWR _0165_ sky130_fd_sc_hd__mux2_1
XFILLER_0_28_62 VPWR VGND VPWR VGND sky130_ef_sc_hd__decap_12
XFILLER_0_44_83 VGND VGND VPWR VPWR sky130_fd_sc_hd__fill_1
X_1017_ clknet_4_2_0_clk _0121_ VGND VGND VPWR VPWR memory\[8\]\[0\] sky130_fd_sc_hd__dfxtp_1
XFILLER_0_8_277 VPWR VGND VPWR VGND sky130_ef_sc_hd__decap_12
XFILLER_0_39_125 VPWR VGND VPWR VGND sky130_ef_sc_hd__decap_12
XFILLER_0_50_301 VGND VGND VPWR VPWR sky130_fd_sc_hd__decap_6
XFILLER_0_47_180 VGND VGND VPWR VPWR sky130_fd_sc_hd__decap_3
XFILLER_0_49_39 VPWR VGND VPWR VGND sky130_ef_sc_hd__decap_12
XFILLER_0_5_203 VPWR VGND VPWR VGND sky130_ef_sc_hd__decap_12
XFILLER_0_30_85 VGND VGND VPWR VPWR sky130_fd_sc_hd__fill_1
XTAP_275 VGND VPWR sky130_fd_sc_hd__tapvpwrvgnd_1
X_0517_ _0196_ VGND VGND VPWR VPWR _0022_ sky130_fd_sc_hd__clkbuf_1
XTAP_220 VGND VPWR sky130_fd_sc_hd__tapvpwrvgnd_1
XTAP_231 VGND VPWR sky130_fd_sc_hd__tapvpwrvgnd_1
XTAP_242 VGND VPWR sky130_fd_sc_hd__tapvpwrvgnd_1
XTAP_253 VGND VPWR sky130_fd_sc_hd__tapvpwrvgnd_1
XTAP_264 VGND VPWR sky130_fd_sc_hd__tapvpwrvgnd_1
XTAP_297 VGND VPWR sky130_fd_sc_hd__tapvpwrvgnd_1
XTAP_286 VGND VPWR sky130_fd_sc_hd__tapvpwrvgnd_1
X_0448_ data_count\[4\] _0151_ VGND VGND VPWR VPWR net12 sky130_fd_sc_hd__nor2_1
XFILLER_0_35_19 VGND VGND VPWR VPWR sky130_fd_sc_hd__fill_1
XFILLER_0_51_29 VGND VGND VPWR VPWR sky130_fd_sc_hd__decap_8
XFILLER_0_35_150 VPWR VGND VPWR VGND sky130_ef_sc_hd__decap_12
XFILLER_0_50_153 VGND VGND VPWR VPWR sky130_fd_sc_hd__fill_1
XFILLER_0_41_73 VPWR VGND VPWR VGND sky130_ef_sc_hd__decap_12
XFILLER_0_18_128 VPWR VGND VPWR VGND sky130_ef_sc_hd__decap_12
X_0997_ clknet_4_15_0_clk _0101_ VGND VGND VPWR VPWR memory\[4\]\[4\] sky130_fd_sc_hd__dfxtp_1
XFILLER_0_1_261 VPWR VGND VPWR VGND sky130_ef_sc_hd__decap_12
XFILLER_0_5_95 VPWR VGND VPWR VGND sky130_ef_sc_hd__decap_12
XFILLER_0_49_220 VGND VGND VPWR VPWR sky130_fd_sc_hd__decap_4
XFILLER_0_32_131 VGND VGND VPWR VPWR sky130_fd_sc_hd__fill_1
XFILLER_0_32_197 VGND VGND VPWR VPWR sky130_fd_sc_hd__decap_6
X_0920_ clknet_4_1_0_clk _0024_ VGND VGND VPWR VPWR memory\[13\]\[7\] sky130_fd_sc_hd__dfxtp_1
XFILLER_0_11_65 VGND VGND VPWR VPWR sky130_fd_sc_hd__fill_2
X_0851_ _0242_ _0221_ _0296_ VGND VGND VPWR VPWR _0411_ sky130_fd_sc_hd__a21oi_1
X_0782_ _0373_ VGND VGND VPWR VPWR _0110_ sky130_fd_sc_hd__clkbuf_1
Xinput3 wr_data[0] VGND VGND VPWR VPWR net3 sky130_fd_sc_hd__buf_2
XFILLER_0_46_289 VPWR VGND VPWR VGND sky130_ef_sc_hd__decap_12
XFILLER_0_14_153 VPWR VGND VPWR VGND sky130_ef_sc_hd__decap_12
XFILLER_0_14_197 VPWR VGND VPWR VGND sky130_ef_sc_hd__decap_12
XFILLER_0_37_278 VGND VGND VPWR VPWR sky130_fd_sc_hd__fill_2
XFILLER_0_20_134 VGND VGND VPWR VPWR sky130_fd_sc_hd__decap_6
XFILLER_0_20_167 VPWR VGND VPWR VGND sky130_ef_sc_hd__decap_12
X_0903_ clknet_4_1_0_clk _0007_ VGND VGND VPWR VPWR memory\[15\]\[7\] sky130_fd_sc_hd__dfxtp_1
XFILLER_0_22_53 VPWR VGND VPWR VGND sky130_ef_sc_hd__decap_12
XFILLER_0_22_97 VPWR VGND VPWR VGND sky130_ef_sc_hd__decap_12
XFILLER_0_28_223 VGND VGND VPWR VPWR sky130_fd_sc_hd__decap_4
X_0834_ _0401_ VGND VGND VPWR VPWR _0134_ sky130_fd_sc_hd__clkbuf_1
XFILLER_0_51_281 VPWR VGND VPWR VGND sky130_ef_sc_hd__decap_12
XFILLER_0_11_178 VGND VGND VPWR VPWR sky130_fd_sc_hd__fill_2
X_0696_ _0326_ VGND VGND VPWR VPWR _0071_ sky130_fd_sc_hd__clkbuf_1
X_0765_ _0364_ VGND VGND VPWR VPWR _0102_ sky130_fd_sc_hd__clkbuf_1
XFILLER_0_2_52 VGND VGND VPWR VPWR sky130_fd_sc_hd__fill_1
XFILLER_0_2_41 VGND VGND VPWR VPWR sky130_fd_sc_hd__decap_8
XFILLER_0_2_85 VPWR VGND VPWR VGND sky130_ef_sc_hd__decap_12
XFILLER_0_2_74 VGND VGND VPWR VPWR sky130_fd_sc_hd__decap_8
XFILLER_0_19_223 VGND VGND VPWR VPWR sky130_fd_sc_hd__fill_1
XPHY_9 VGND VGND VPWR VPWR sky130_fd_sc_hd__decap_3
X_0550_ _0215_ VGND VGND VPWR VPWR _0036_ sky130_fd_sc_hd__clkbuf_1
XFILLER_0_40_218 VPWR VGND VPWR VGND sky130_ef_sc_hd__decap_12
XFILLER_0_33_281 VPWR VGND VPWR VGND sky130_ef_sc_hd__decap_12
XFILLER_0_25_259 VGND VGND VPWR VPWR sky130_fd_sc_hd__decap_4
X_0481_ _0175_ VGND VGND VPWR VPWR _0007_ sky130_fd_sc_hd__clkbuf_1
X_1033_ clknet_4_14_0_clk _0137_ VGND VGND VPWR VPWR net14 sky130_fd_sc_hd__dfxtp_1
XFILLER_0_16_9 VPWR VGND VPWR VGND sky130_ef_sc_hd__decap_12
X_0817_ _0392_ VGND VGND VPWR VPWR _0126_ sky130_fd_sc_hd__clkbuf_1
X_0679_ _0317_ VGND VGND VPWR VPWR _0063_ sky130_fd_sc_hd__clkbuf_1
X_0748_ _0172_ net145 _0348_ VGND VGND VPWR VPWR _0355_ sky130_fd_sc_hd__mux2_1
XFILLER_0_15_281 VPWR VGND VPWR VGND sky130_ef_sc_hd__decap_12
XFILLER_0_22_218 VGND VGND VPWR VPWR sky130_fd_sc_hd__decap_4
Xhold108 memory\[14\]\[5\] VGND VGND VPWR VPWR net133 sky130_fd_sc_hd__dlygate4sd3_1
XFILLER_0_13_207 VPWR VGND VPWR VGND sky130_ef_sc_hd__decap_12
X_0533_ net66 _0168_ _0201_ VGND VGND VPWR VPWR _0206_ sky130_fd_sc_hd__mux2_1
Xhold119 memory\[1\]\[6\] VGND VGND VPWR VPWR net144 sky130_fd_sc_hd__dlygate4sd3_1
X_0464_ net5 VGND VGND VPWR VPWR _0164_ sky130_fd_sc_hd__buf_2
XFILLER_0_0_167 VGND VGND VPWR VPWR sky130_fd_sc_hd__fill_1
X_0602_ memory\[8\]\[3\] memory\[9\]\[3\] memory\[10\]\[3\] memory\[11\]\[3\] _0242_
+ _0243_ VGND VGND VPWR VPWR _0260_ sky130_fd_sc_hd__mux4_1
XFILLER_0_28_41 VGND VGND VPWR VPWR sky130_fd_sc_hd__decap_4
XFILLER_0_28_74 VGND VGND VPWR VPWR sky130_fd_sc_hd__decap_8
XFILLER_0_28_85 VPWR VGND VPWR VGND sky130_ef_sc_hd__decap_12
X_1016_ clknet_4_5_0_clk _0120_ VGND VGND VPWR VPWR memory\[5\]\[7\] sky130_fd_sc_hd__dfxtp_1
XFILLER_0_8_245 VGND VGND VPWR VPWR sky130_fd_sc_hd__decap_6
XFILLER_0_8_289 VPWR VGND VPWR VGND sky130_ef_sc_hd__decap_12
XFILLER_0_39_137 VPWR VGND VPWR VGND sky130_ef_sc_hd__decap_12
XFILLER_0_38_181 VGND VGND VPWR VPWR sky130_fd_sc_hd__fill_1
XFILLER_0_5_215 VGND VGND VPWR VPWR sky130_fd_sc_hd__decap_8
XFILLER_0_30_64 VGND VGND VPWR VPWR sky130_fd_sc_hd__decap_8
XFILLER_0_39_51 VGND VGND VPWR VPWR sky130_fd_sc_hd__decap_4
XTAP_298 VGND VPWR sky130_fd_sc_hd__tapvpwrvgnd_1
XTAP_287 VGND VPWR sky130_fd_sc_hd__tapvpwrvgnd_1
XTAP_276 VGND VPWR sky130_fd_sc_hd__tapvpwrvgnd_1
X_0516_ _0170_ net138 _0190_ VGND VGND VPWR VPWR _0196_ sky130_fd_sc_hd__mux2_1
XTAP_210 VGND VPWR sky130_fd_sc_hd__tapvpwrvgnd_1
XTAP_221 VGND VPWR sky130_fd_sc_hd__tapvpwrvgnd_1
XTAP_232 VGND VPWR sky130_fd_sc_hd__tapvpwrvgnd_1
X_0447_ data_count\[3\] data_count\[2\] data_count\[1\] data_count\[0\] VGND VGND
+ VPWR VPWR _0151_ sky130_fd_sc_hd__or4_2
XTAP_243 VGND VPWR sky130_fd_sc_hd__tapvpwrvgnd_1
XTAP_254 VGND VPWR sky130_fd_sc_hd__tapvpwrvgnd_1
XTAP_265 VGND VPWR sky130_fd_sc_hd__tapvpwrvgnd_1
XFILLER_0_12_3 VGND VGND VPWR VPWR sky130_fd_sc_hd__fill_1
XFILLER_0_36_107 VGND VGND VPWR VPWR sky130_fd_sc_hd__decap_3
XFILLER_0_44_195 VGND VGND VPWR VPWR sky130_fd_sc_hd__fill_1
XFILLER_0_51_19 VGND VGND VPWR VPWR sky130_fd_sc_hd__decap_8
XFILLER_0_27_107 VGND VGND VPWR VPWR sky130_fd_sc_hd__decap_4
XFILLER_0_50_165 VGND VGND VPWR VPWR sky130_fd_sc_hd__fill_1
XFILLER_0_35_162 VGND VGND VPWR VPWR sky130_fd_sc_hd__decap_6
X_0996_ clknet_4_7_0_clk _0100_ VGND VGND VPWR VPWR memory\[4\]\[3\] sky130_fd_sc_hd__dfxtp_1
XFILLER_0_41_85 VPWR VGND VPWR VGND sky130_ef_sc_hd__decap_12
XFILLER_0_41_143 VGND VGND VPWR VPWR sky130_fd_sc_hd__decap_3
XFILLER_0_1_273 VGND VGND VPWR VPWR sky130_fd_sc_hd__decap_6
XFILLER_0_26_195 VGND VGND VPWR VPWR sky130_fd_sc_hd__fill_1
XFILLER_0_46_19 VGND VGND VPWR VPWR sky130_fd_sc_hd__decap_8
XFILLER_0_1_3 VPWR VGND VPWR VGND sky130_ef_sc_hd__decap_12
X_0850_ _0296_ _0410_ VGND VGND VPWR VPWR _0141_ sky130_fd_sc_hd__nor2_1
XFILLER_0_11_305 VGND VGND VPWR VPWR sky130_fd_sc_hd__fill_2
X_0781_ net49 net8 _0367_ VGND VGND VPWR VPWR _0373_ sky130_fd_sc_hd__mux2_1
Xinput4 wr_data[1] VGND VGND VPWR VPWR net4 sky130_fd_sc_hd__buf_2
X_0979_ clknet_4_10_0_clk _0083_ VGND VGND VPWR VPWR memory\[9\]\[2\] sky130_fd_sc_hd__dfxtp_1
XFILLER_0_14_165 VGND VGND VPWR VPWR sky130_fd_sc_hd__decap_8
XFILLER_0_9_181 VPWR VGND VPWR VGND sky130_ef_sc_hd__decap_12
XFILLER_0_20_113 VGND VGND VPWR VPWR sky130_fd_sc_hd__decap_6
X_0902_ clknet_4_0_0_clk _0006_ VGND VGND VPWR VPWR memory\[15\]\[6\] sky130_fd_sc_hd__dfxtp_1
XFILLER_0_22_65 VGND VGND VPWR VPWR sky130_fd_sc_hd__decap_8
X_0833_ _0170_ net118 _0395_ VGND VGND VPWR VPWR _0401_ sky130_fd_sc_hd__mux2_1
XFILLER_0_51_293 VGND VGND VPWR VPWR sky130_fd_sc_hd__decap_8
XFILLER_0_51_7 VPWR VGND VPWR VGND sky130_ef_sc_hd__decap_12
XFILLER_0_11_113 VGND VGND VPWR VPWR sky130_fd_sc_hd__fill_2
X_0695_ _0172_ net159 _0319_ VGND VGND VPWR VPWR _0326_ sky130_fd_sc_hd__mux2_1
X_0764_ net60 net8 _0358_ VGND VGND VPWR VPWR _0364_ sky130_fd_sc_hd__mux2_1
XFILLER_0_47_95 VGND VGND VPWR VPWR sky130_fd_sc_hd__decap_4
XFILLER_0_47_51 VGND VGND VPWR VPWR sky130_fd_sc_hd__fill_2
XFILLER_0_2_97 VGND VGND VPWR VPWR sky130_fd_sc_hd__decap_4
XFILLER_0_19_279 VGND VGND VPWR VPWR sky130_fd_sc_hd__fill_1
XFILLER_0_34_249 VGND VGND VPWR VPWR sky130_fd_sc_hd__decap_3
XFILLER_0_6_195 VGND VGND VPWR VPWR sky130_fd_sc_hd__fill_1
XFILLER_0_33_293 VPWR VGND VPWR VGND sky130_ef_sc_hd__decap_12
XFILLER_0_33_260 VPWR VGND VPWR VGND sky130_ef_sc_hd__decap_12
X_0480_ net40 _0174_ _0160_ VGND VGND VPWR VPWR _0175_ sky130_fd_sc_hd__mux2_1
X_1032_ clknet_4_5_0_clk _0136_ VGND VGND VPWR VPWR memory\[6\]\[7\] sky130_fd_sc_hd__dfxtp_1
XFILLER_0_17_21 VGND VGND VPWR VPWR sky130_fd_sc_hd__fill_1
X_0747_ _0354_ VGND VGND VPWR VPWR _0094_ sky130_fd_sc_hd__clkbuf_1
X_0816_ net128 net8 _0386_ VGND VGND VPWR VPWR _0392_ sky130_fd_sc_hd__mux2_1
XFILLER_0_42_3 VGND VGND VPWR VPWR sky130_fd_sc_hd__decap_8
X_0678_ net95 net9 _0310_ VGND VGND VPWR VPWR _0317_ sky130_fd_sc_hd__mux2_1
XFILLER_0_15_293 VPWR VGND VPWR VGND sky130_ef_sc_hd__decap_12
Xhold109 memory\[12\]\[5\] VGND VGND VPWR VPWR net134 sky130_fd_sc_hd__dlygate4sd3_1
XFILLER_0_13_219 VGND VGND VPWR VPWR sky130_fd_sc_hd__decap_4
X_0601_ read_pointer\[3\] _0258_ VGND VGND VPWR VPWR _0259_ sky130_fd_sc_hd__and2b_1
X_0532_ _0205_ VGND VGND VPWR VPWR _0028_ sky130_fd_sc_hd__clkbuf_1
X_0463_ _0163_ VGND VGND VPWR VPWR _0001_ sky130_fd_sc_hd__clkbuf_1
XFILLER_0_0_113 VPWR VGND VPWR VGND sky130_ef_sc_hd__decap_12
XFILLER_0_44_85 VGND VGND VPWR VPWR sky130_fd_sc_hd__fill_2
XFILLER_0_44_41 VPWR VGND VPWR VGND sky130_ef_sc_hd__decap_12
X_1015_ clknet_4_4_0_clk _0119_ VGND VGND VPWR VPWR memory\[5\]\[6\] sky130_fd_sc_hd__dfxtp_1
XFILLER_0_28_97 VPWR VGND VPWR VGND sky130_ef_sc_hd__decap_12
XFILLER_0_12_241 VGND VGND VPWR VPWR sky130_fd_sc_hd__decap_8
XFILLER_0_12_285 VGND VGND VPWR VPWR sky130_fd_sc_hd__decap_3
XFILLER_0_39_149 VGND VGND VPWR VPWR sky130_fd_sc_hd__decap_8
XFILLER_0_38_193 VGND VGND VPWR VPWR sky130_fd_sc_hd__decap_3
XFILLER_0_14_55 VGND VGND VPWR VPWR sky130_fd_sc_hd__fill_1
XFILLER_0_26_300 VGND VGND VPWR VPWR sky130_fd_sc_hd__decap_3
XFILLER_0_39_85 VGND VGND VPWR VPWR sky130_fd_sc_hd__decap_4
XTAP_299 VGND VPWR sky130_fd_sc_hd__tapvpwrvgnd_1
XTAP_288 VGND VPWR sky130_fd_sc_hd__tapvpwrvgnd_1
XTAP_277 VGND VPWR sky130_fd_sc_hd__tapvpwrvgnd_1
XTAP_200 VGND VPWR sky130_fd_sc_hd__tapvpwrvgnd_1
X_0515_ _0195_ VGND VGND VPWR VPWR _0021_ sky130_fd_sc_hd__clkbuf_1
XTAP_211 VGND VPWR sky130_fd_sc_hd__tapvpwrvgnd_1
XTAP_222 VGND VPWR sky130_fd_sc_hd__tapvpwrvgnd_1
XTAP_233 VGND VPWR sky130_fd_sc_hd__tapvpwrvgnd_1
XTAP_244 VGND VPWR sky130_fd_sc_hd__tapvpwrvgnd_1
XTAP_255 VGND VPWR sky130_fd_sc_hd__tapvpwrvgnd_1
XTAP_266 VGND VPWR sky130_fd_sc_hd__tapvpwrvgnd_1
XFILLER_0_44_141 VPWR VGND VPWR VGND sky130_ef_sc_hd__decap_12
XFILLER_0_44_130 VGND VGND VPWR VPWR sky130_fd_sc_hd__decap_8
XFILLER_0_50_122 VPWR VGND VPWR VGND sky130_ef_sc_hd__decap_12
XFILLER_0_41_97 VGND VGND VPWR VPWR sky130_fd_sc_hd__decap_6
X_0995_ clknet_4_12_0_clk _0099_ VGND VGND VPWR VPWR memory\[4\]\[2\] sky130_fd_sc_hd__dfxtp_1
XFILLER_0_26_141 VGND VGND VPWR VPWR sky130_fd_sc_hd__decap_8
X_0780_ _0372_ VGND VGND VPWR VPWR _0109_ sky130_fd_sc_hd__clkbuf_1
XFILLER_0_23_111 VGND VGND VPWR VPWR sky130_fd_sc_hd__fill_1
Xinput5 wr_data[2] VGND VGND VPWR VPWR net5 sky130_fd_sc_hd__buf_2
XFILLER_0_46_214 VPWR VGND VPWR VGND sky130_ef_sc_hd__decap_12
X_0978_ clknet_4_9_0_clk _0082_ VGND VGND VPWR VPWR memory\[9\]\[1\] sky130_fd_sc_hd__dfxtp_1
XFILLER_0_9_193 VGND VGND VPWR VPWR sky130_fd_sc_hd__decap_6
X_0763_ _0363_ VGND VGND VPWR VPWR _0101_ sky130_fd_sc_hd__clkbuf_1
X_0832_ _0400_ VGND VGND VPWR VPWR _0133_ sky130_fd_sc_hd__clkbuf_1
X_0901_ clknet_4_0_0_clk _0005_ VGND VGND VPWR VPWR memory\[15\]\[5\] sky130_fd_sc_hd__dfxtp_1
X_0694_ _0325_ VGND VGND VPWR VPWR _0070_ sky130_fd_sc_hd__clkbuf_1
XFILLER_0_6_141 VGND VGND VPWR VPWR sky130_fd_sc_hd__decap_6
XFILLER_0_42_261 VPWR VGND VPWR VGND sky130_ef_sc_hd__decap_12
XFILLER_0_33_272 VGND VGND VPWR VPWR sky130_fd_sc_hd__decap_8
Xclkbuf_4_9_0_clk clknet_0_clk VGND VGND VPWR VPWR clknet_4_9_0_clk sky130_fd_sc_hd__clkbuf_8
X_1031_ clknet_4_5_0_clk _0135_ VGND VGND VPWR VPWR memory\[6\]\[6\] sky130_fd_sc_hd__dfxtp_1
XFILLER_0_17_44 VGND VGND VPWR VPWR sky130_fd_sc_hd__fill_1
XFILLER_0_16_206 VGND VGND VPWR VPWR sky130_fd_sc_hd__fill_1
X_0746_ _0170_ net158 _0348_ VGND VGND VPWR VPWR _0354_ sky130_fd_sc_hd__mux2_1
X_0815_ _0391_ VGND VGND VPWR VPWR _0125_ sky130_fd_sc_hd__clkbuf_1
XFILLER_0_24_261 VGND VGND VPWR VPWR sky130_fd_sc_hd__fill_2
XFILLER_0_24_272 VGND VGND VPWR VPWR sky130_fd_sc_hd__fill_1
XFILLER_0_35_3 VPWR VGND VPWR VGND sky130_ef_sc_hd__decap_12
X_0677_ _0316_ VGND VGND VPWR VPWR _0062_ sky130_fd_sc_hd__clkbuf_1
XFILLER_0_30_253 VPWR VGND VPWR VGND sky130_ef_sc_hd__decap_12
X_0600_ _0256_ _0257_ read_pointer\[2\] VGND VGND VPWR VPWR _0258_ sky130_fd_sc_hd__mux2_1
X_0531_ net72 _0166_ _0201_ VGND VGND VPWR VPWR _0205_ sky130_fd_sc_hd__mux2_1
XFILLER_0_0_125 VPWR VGND VPWR VGND sky130_ef_sc_hd__decap_12
X_0462_ net56 _0162_ _0160_ VGND VGND VPWR VPWR _0163_ sky130_fd_sc_hd__mux2_1
XFILLER_0_0_169 VPWR VGND VPWR VGND sky130_ef_sc_hd__decap_12
XFILLER_0_21_286 VGND VGND VPWR VPWR sky130_fd_sc_hd__decap_3
XFILLER_0_48_139 VGND VGND VPWR VPWR sky130_fd_sc_hd__fill_1
XFILLER_0_44_53 VPWR VGND VPWR VGND sky130_ef_sc_hd__decap_12
X_1014_ clknet_4_4_0_clk _0118_ VGND VGND VPWR VPWR memory\[5\]\[5\] sky130_fd_sc_hd__dfxtp_1
XFILLER_0_44_301 VGND VGND VPWR VPWR sky130_fd_sc_hd__decap_6
X_0729_ _0170_ net135 _0339_ VGND VGND VPWR VPWR _0345_ sky130_fd_sc_hd__mux2_1
XFILLER_0_12_253 VPWR VGND VPWR VGND sky130_ef_sc_hd__decap_12
XFILLER_0_47_161 VGND VGND VPWR VPWR sky130_fd_sc_hd__decap_6
XFILLER_0_35_301 VGND VGND VPWR VPWR sky130_fd_sc_hd__fill_2
XFILLER_0_14_78 VGND VGND VPWR VPWR sky130_fd_sc_hd__decap_6
XFILLER_0_30_11 VGND VGND VPWR VPWR sky130_fd_sc_hd__fill_1
X_0514_ _0168_ net87 _0190_ VGND VGND VPWR VPWR _0195_ sky130_fd_sc_hd__mux2_1
XTAP_201 VGND VPWR sky130_fd_sc_hd__tapvpwrvgnd_1
XTAP_212 VGND VPWR sky130_fd_sc_hd__tapvpwrvgnd_1
XTAP_223 VGND VPWR sky130_fd_sc_hd__tapvpwrvgnd_1
XFILLER_0_39_97 VPWR VGND VPWR VGND sky130_ef_sc_hd__decap_12
XTAP_289 VGND VPWR sky130_fd_sc_hd__tapvpwrvgnd_1
XTAP_278 VGND VPWR sky130_fd_sc_hd__tapvpwrvgnd_1
XTAP_234 VGND VPWR sky130_fd_sc_hd__tapvpwrvgnd_1
XTAP_245 VGND VPWR sky130_fd_sc_hd__tapvpwrvgnd_1
XTAP_256 VGND VPWR sky130_fd_sc_hd__tapvpwrvgnd_1
XTAP_267 VGND VPWR sky130_fd_sc_hd__tapvpwrvgnd_1
XFILLER_0_44_197 VPWR VGND VPWR VGND sky130_ef_sc_hd__decap_12
XFILLER_0_44_153 VPWR VGND VPWR VGND sky130_ef_sc_hd__decap_12
XFILLER_0_4_250 VGND VGND VPWR VPWR sky130_fd_sc_hd__fill_2
XFILLER_0_50_134 VGND VGND VPWR VPWR sky130_fd_sc_hd__decap_6
X_0994_ clknet_4_13_0_clk _0098_ VGND VGND VPWR VPWR memory\[4\]\[1\] sky130_fd_sc_hd__dfxtp_1
XFILLER_0_26_175 VGND VGND VPWR VPWR sky130_fd_sc_hd__fill_1
XFILLER_0_5_65 VGND VGND VPWR VPWR sky130_fd_sc_hd__fill_2
XFILLER_0_17_142 VGND VGND VPWR VPWR sky130_fd_sc_hd__decap_3
XFILLER_0_32_101 VPWR VGND VPWR VGND sky130_ef_sc_hd__decap_12
XFILLER_0_11_57 VGND VGND VPWR VPWR sky130_fd_sc_hd__decap_8
Xinput6 wr_data[3] VGND VGND VPWR VPWR net6 sky130_fd_sc_hd__buf_2
XFILLER_0_46_226 VPWR VGND VPWR VGND sky130_ef_sc_hd__decap_12
X_0977_ clknet_4_2_0_clk _0081_ VGND VGND VPWR VPWR memory\[9\]\[0\] sky130_fd_sc_hd__dfxtp_1
XFILLER_0_37_204 VGND VGND VPWR VPWR sky130_fd_sc_hd__decap_4
XFILLER_0_45_281 VPWR VGND VPWR VGND sky130_ef_sc_hd__decap_12
XPHY_90 VGND VGND VPWR VPWR sky130_fd_sc_hd__decap_3
X_0900_ clknet_4_3_0_clk _0004_ VGND VGND VPWR VPWR memory\[15\]\[4\] sky130_fd_sc_hd__dfxtp_1
X_0762_ net34 net7 _0358_ VGND VGND VPWR VPWR _0363_ sky130_fd_sc_hd__mux2_1
X_0831_ _0168_ net152 _0395_ VGND VGND VPWR VPWR _0400_ sky130_fd_sc_hd__mux2_1
X_0693_ _0170_ net133 _0319_ VGND VGND VPWR VPWR _0325_ sky130_fd_sc_hd__mux2_1
XFILLER_0_27_281 VPWR VGND VPWR VGND sky130_ef_sc_hd__decap_12
XFILLER_0_42_273 VPWR VGND VPWR VGND sky130_ef_sc_hd__decap_12
Xmax_cap24 net25 VGND VGND VPWR VPWR net24 sky130_fd_sc_hd__buf_1
XFILLER_0_25_218 VGND VGND VPWR VPWR sky130_fd_sc_hd__decap_6
X_1030_ clknet_4_4_0_clk _0134_ VGND VGND VPWR VPWR memory\[6\]\[5\] sky130_fd_sc_hd__dfxtp_1
XFILLER_0_33_55 VGND VGND VPWR VPWR sky130_fd_sc_hd__fill_1
X_0814_ net42 net7 _0386_ VGND VGND VPWR VPWR _0391_ sky130_fd_sc_hd__mux2_1
X_0676_ net63 net8 _0310_ VGND VGND VPWR VPWR _0316_ sky130_fd_sc_hd__mux2_1
X_0745_ _0353_ VGND VGND VPWR VPWR _0093_ sky130_fd_sc_hd__clkbuf_1
XFILLER_0_28_3 VPWR VGND VPWR VGND sky130_ef_sc_hd__decap_12
XFILLER_0_30_221 VGND VGND VPWR VPWR sky130_fd_sc_hd__fill_2
XFILLER_0_30_265 VGND VGND VPWR VPWR sky130_fd_sc_hd__decap_4
X_0530_ _0204_ VGND VGND VPWR VPWR _0027_ sky130_fd_sc_hd__clkbuf_1
XFILLER_0_0_137 VGND VGND VPWR VPWR sky130_fd_sc_hd__decap_3
X_0461_ net4 VGND VGND VPWR VPWR _0162_ sky130_fd_sc_hd__buf_2
XFILLER_0_44_65 VPWR VGND VPWR VGND sky130_ef_sc_hd__decap_12
X_1013_ clknet_4_13_0_clk _0117_ VGND VGND VPWR VPWR memory\[5\]\[4\] sky130_fd_sc_hd__dfxtp_1
X_0659_ net134 net8 _0301_ VGND VGND VPWR VPWR _0307_ sky130_fd_sc_hd__mux2_1
XFILLER_0_12_265 VPWR VGND VPWR VGND sky130_ef_sc_hd__decap_12
X_0728_ _0344_ VGND VGND VPWR VPWR _0085_ sky130_fd_sc_hd__clkbuf_1
Xclkbuf_4_8_0_clk clknet_0_clk VGND VGND VPWR VPWR clknet_4_8_0_clk sky130_fd_sc_hd__clkbuf_8
XFILLER_0_7_281 VPWR VGND VPWR VGND sky130_ef_sc_hd__decap_12
XFILLER_0_41_305 VGND VGND VPWR VPWR sky130_fd_sc_hd__fill_2
XFILLER_0_39_65 VGND VGND VPWR VPWR sky130_fd_sc_hd__fill_1
XTAP_202 VGND VPWR sky130_fd_sc_hd__tapvpwrvgnd_1
XTAP_213 VGND VPWR sky130_fd_sc_hd__tapvpwrvgnd_1
XTAP_224 VGND VPWR sky130_fd_sc_hd__tapvpwrvgnd_1
XTAP_235 VGND VPWR sky130_fd_sc_hd__tapvpwrvgnd_1
X_0513_ _0194_ VGND VGND VPWR VPWR _0020_ sky130_fd_sc_hd__clkbuf_1
XTAP_246 VGND VPWR sky130_fd_sc_hd__tapvpwrvgnd_1
XTAP_257 VGND VPWR sky130_fd_sc_hd__tapvpwrvgnd_1
XTAP_279 VGND VPWR sky130_fd_sc_hd__tapvpwrvgnd_1
XTAP_268 VGND VPWR sky130_fd_sc_hd__tapvpwrvgnd_1
XFILLER_0_44_165 VPWR VGND VPWR VGND sky130_ef_sc_hd__decap_12
XFILLER_0_32_305 VGND VGND VPWR VPWR sky130_fd_sc_hd__fill_2
XFILLER_0_35_110 VGND VGND VPWR VPWR sky130_fd_sc_hd__fill_2
XFILLER_0_50_157 VGND VGND VPWR VPWR sky130_fd_sc_hd__decap_8
X_0993_ clknet_4_12_0_clk _0097_ VGND VGND VPWR VPWR memory\[4\]\[0\] sky130_fd_sc_hd__dfxtp_1
XFILLER_0_10_3 VPWR VGND VPWR VGND sky130_ef_sc_hd__decap_12
XFILLER_0_49_279 VGND VGND VPWR VPWR sky130_fd_sc_hd__fill_1
XFILLER_0_32_113 VPWR VGND VPWR VGND sky130_ef_sc_hd__decap_12
XFILLER_0_23_113 VGND VGND VPWR VPWR sky130_fd_sc_hd__decap_4
XFILLER_0_36_11 VGND VGND VPWR VPWR sky130_fd_sc_hd__fill_1
Xinput7 wr_data[4] VGND VGND VPWR VPWR net7 sky130_fd_sc_hd__buf_2
XFILLER_0_46_238 VPWR VGND VPWR VGND sky130_ef_sc_hd__decap_12
X_0976_ clknet_4_1_0_clk _0080_ VGND VGND VPWR VPWR memory\[11\]\[7\] sky130_fd_sc_hd__dfxtp_1
XFILLER_0_14_179 VPWR VGND VPWR VGND sky130_ef_sc_hd__decap_12
XFILLER_0_45_293 VPWR VGND VPWR VGND sky130_ef_sc_hd__decap_12
XFILLER_0_20_149 VPWR VGND VPWR VGND sky130_ef_sc_hd__decap_12
XPHY_91 VGND VGND VPWR VPWR sky130_fd_sc_hd__decap_3
X_0830_ _0399_ VGND VGND VPWR VPWR _0132_ sky130_fd_sc_hd__clkbuf_1
XPHY_80 VGND VGND VPWR VPWR sky130_fd_sc_hd__decap_3
XFILLER_0_28_227 VGND VGND VPWR VPWR sky130_fd_sc_hd__fill_1
X_0761_ _0362_ VGND VGND VPWR VPWR _0100_ sky130_fd_sc_hd__clkbuf_1
XFILLER_0_3_305 VGND VGND VPWR VPWR sky130_fd_sc_hd__fill_2
X_0692_ _0324_ VGND VGND VPWR VPWR _0069_ sky130_fd_sc_hd__clkbuf_1
XFILLER_0_19_205 VPWR VGND VPWR VGND sky130_ef_sc_hd__decap_12
X_0959_ clknet_4_7_0_clk _0063_ VGND VGND VPWR VPWR memory\[3\]\[6\] sky130_fd_sc_hd__dfxtp_1
XFILLER_0_6_176 VGND VGND VPWR VPWR sky130_fd_sc_hd__decap_6
XFILLER_0_6_121 VPWR VGND VPWR VGND sky130_ef_sc_hd__decap_12
XFILLER_0_27_293 VPWR VGND VPWR VGND sky130_ef_sc_hd__decap_12
XFILLER_0_42_285 VPWR VGND VPWR VGND sky130_ef_sc_hd__decap_12
Xmax_cap25 _0152_ VGND VGND VPWR VPWR net25 sky130_fd_sc_hd__clkbuf_1
XFILLER_0_17_57 VPWR VGND VPWR VGND sky130_ef_sc_hd__decap_12
Xinput10 wr_data[7] VGND VGND VPWR VPWR net10 sky130_fd_sc_hd__buf_2
X_0813_ _0390_ VGND VGND VPWR VPWR _0124_ sky130_fd_sc_hd__clkbuf_1
X_0675_ _0315_ VGND VGND VPWR VPWR _0061_ sky130_fd_sc_hd__clkbuf_1
XFILLER_0_3_179 VGND VGND VPWR VPWR sky130_fd_sc_hd__decap_3
X_0744_ _0168_ net123 _0348_ VGND VGND VPWR VPWR _0353_ sky130_fd_sc_hd__mux2_1
XFILLER_0_2_190 VGND VGND VPWR VPWR sky130_fd_sc_hd__decap_3
XFILLER_0_30_299 VGND VGND VPWR VPWR sky130_fd_sc_hd__decap_8
X_0460_ _0161_ VGND VGND VPWR VPWR _0000_ sky130_fd_sc_hd__clkbuf_1
XFILLER_0_0_105 VGND VGND VPWR VPWR sky130_fd_sc_hd__decap_6
XFILLER_0_21_222 VGND VGND VPWR VPWR sky130_fd_sc_hd__fill_2
X_1012_ clknet_4_7_0_clk _0116_ VGND VGND VPWR VPWR memory\[5\]\[3\] sky130_fd_sc_hd__dfxtp_1
XFILLER_0_28_45 VGND VGND VPWR VPWR sky130_fd_sc_hd__fill_1
XFILLER_0_44_77 VGND VGND VPWR VPWR sky130_fd_sc_hd__decap_6
X_0727_ _0168_ net67 _0339_ VGND VGND VPWR VPWR _0344_ sky130_fd_sc_hd__mux2_1
XFILLER_0_40_3 VPWR VGND VPWR VGND sky130_ef_sc_hd__decap_12
X_0589_ memory\[0\]\[2\] memory\[1\]\[2\] memory\[2\]\[2\] memory\[3\]\[2\] _0231_
+ _0237_ VGND VGND VPWR VPWR _0248_ sky130_fd_sc_hd__mux4_1
XFILLER_0_12_277 VGND VGND VPWR VPWR sky130_fd_sc_hd__decap_8
X_0658_ _0306_ VGND VGND VPWR VPWR _0053_ sky130_fd_sc_hd__clkbuf_1
XFILLER_0_7_293 VPWR VGND VPWR VGND sky130_ef_sc_hd__decap_12
XFILLER_0_38_141 VPWR VGND VPWR VGND sky130_ef_sc_hd__decap_12
XFILLER_0_14_25 VGND VGND VPWR VPWR sky130_fd_sc_hd__decap_3
XFILLER_0_39_55 VGND VGND VPWR VPWR sky130_fd_sc_hd__fill_1
XTAP_203 VGND VPWR sky130_fd_sc_hd__tapvpwrvgnd_1
XTAP_214 VGND VPWR sky130_fd_sc_hd__tapvpwrvgnd_1
XTAP_225 VGND VPWR sky130_fd_sc_hd__tapvpwrvgnd_1
X_0512_ _0166_ net117 _0190_ VGND VGND VPWR VPWR _0194_ sky130_fd_sc_hd__mux2_1
XTAP_236 VGND VPWR sky130_fd_sc_hd__tapvpwrvgnd_1
XTAP_247 VGND VPWR sky130_fd_sc_hd__tapvpwrvgnd_1
XTAP_258 VGND VPWR sky130_fd_sc_hd__tapvpwrvgnd_1
XTAP_269 VGND VPWR sky130_fd_sc_hd__tapvpwrvgnd_1
XFILLER_0_44_177 VPWR VGND VPWR VGND sky130_ef_sc_hd__decap_12
XFILLER_0_4_230 VPWR VGND VPWR VGND sky130_ef_sc_hd__decap_12
XFILLER_0_25_57 VGND VGND VPWR VPWR sky130_fd_sc_hd__decap_8
XFILLER_0_25_68 VGND VGND VPWR VPWR sky130_fd_sc_hd__decap_4
XFILLER_0_41_23 VGND VGND VPWR VPWR sky130_fd_sc_hd__fill_1
X_0992_ clknet_4_1_0_clk _0096_ VGND VGND VPWR VPWR memory\[10\]\[7\] sky130_fd_sc_hd__dfxtp_1
XFILLER_0_41_169 VGND VGND VPWR VPWR sky130_fd_sc_hd__decap_6
XFILLER_0_14_306 VGND VGND VPWR VPWR sky130_fd_sc_hd__fill_1
Xclkbuf_4_7_0_clk clknet_0_clk VGND VGND VPWR VPWR clknet_4_7_0_clk sky130_fd_sc_hd__clkbuf_8
XFILLER_0_49_225 VPWR VGND VPWR VGND sky130_ef_sc_hd__decap_12
XFILLER_0_32_125 VGND VGND VPWR VPWR sky130_fd_sc_hd__decap_6
XFILLER_0_17_111 VGND VGND VPWR VPWR sky130_fd_sc_hd__fill_1
XFILLER_0_17_122 VGND VGND VPWR VPWR sky130_fd_sc_hd__decap_4
XFILLER_0_32_169 VPWR VGND VPWR VGND sky130_ef_sc_hd__decap_12
XFILLER_0_11_48 VGND VGND VPWR VPWR sky130_fd_sc_hd__decap_8
XFILLER_0_23_103 VGND VGND VPWR VPWR sky130_fd_sc_hd__decap_8
XFILLER_0_23_169 VGND VGND VPWR VPWR sky130_fd_sc_hd__decap_8
Xinput8 wr_data[5] VGND VGND VPWR VPWR net8 sky130_fd_sc_hd__buf_2
X_0975_ clknet_4_0_0_clk _0079_ VGND VGND VPWR VPWR memory\[11\]\[6\] sky130_fd_sc_hd__dfxtp_1
XFILLER_0_22_191 VGND VGND VPWR VPWR sky130_fd_sc_hd__decap_4
XFILLER_0_45_261 VPWR VGND VPWR VGND sky130_ef_sc_hd__decap_12
XPHY_92 VGND VGND VPWR VPWR sky130_fd_sc_hd__decap_3
XFILLER_0_43_209 VGND VGND VPWR VPWR sky130_fd_sc_hd__fill_2
XPHY_81 VGND VGND VPWR VPWR sky130_fd_sc_hd__decap_3
X_0760_ net100 net6 _0358_ VGND VGND VPWR VPWR _0362_ sky130_fd_sc_hd__mux2_1
XPHY_70 VGND VGND VPWR VPWR sky130_fd_sc_hd__decap_3
XFILLER_0_28_217 VGND VGND VPWR VPWR sky130_fd_sc_hd__decap_3
XFILLER_0_51_253 VPWR VGND VPWR VGND sky130_ef_sc_hd__decap_12
X_0691_ _0168_ net154 _0319_ VGND VGND VPWR VPWR _0324_ sky130_fd_sc_hd__mux2_1
XFILLER_0_47_99 VGND VGND VPWR VPWR sky130_fd_sc_hd__fill_1
XFILLER_0_19_217 VGND VGND VPWR VPWR sky130_fd_sc_hd__decap_6
XFILLER_0_42_297 VGND VGND VPWR VPWR sky130_fd_sc_hd__decap_8
XFILLER_0_6_133 VGND VGND VPWR VPWR sky130_fd_sc_hd__decap_6
X_0889_ _0435_ _0436_ _0419_ _0424_ _0429_ VGND VGND VPWR VPWR _0441_ sky130_fd_sc_hd__o2111a_1
XFILLER_0_27_250 VPWR VGND VPWR VGND sky130_ef_sc_hd__decap_12
X_0958_ clknet_4_6_0_clk _0062_ VGND VGND VPWR VPWR memory\[3\]\[5\] sky130_fd_sc_hd__dfxtp_1
XFILLER_0_10_150 VGND VGND VPWR VPWR sky130_fd_sc_hd__decap_8
XFILLER_0_25_209 VGND VGND VPWR VPWR sky130_fd_sc_hd__decap_4
XFILLER_0_17_69 VPWR VGND VPWR VGND sky130_ef_sc_hd__decap_12
XFILLER_0_33_57 VGND VGND VPWR VPWR sky130_fd_sc_hd__decap_6
XFILLER_0_3_169 VGND VGND VPWR VPWR sky130_fd_sc_hd__fill_1
Xinput11 wr_en VGND VGND VPWR VPWR net11 sky130_fd_sc_hd__buf_1
X_0812_ net45 net6 _0386_ VGND VGND VPWR VPWR _0390_ sky130_fd_sc_hd__mux2_1
XFILLER_0_24_253 VGND VGND VPWR VPWR sky130_fd_sc_hd__decap_8
X_0743_ _0352_ VGND VGND VPWR VPWR _0092_ sky130_fd_sc_hd__clkbuf_1
X_0674_ net29 net7 _0310_ VGND VGND VPWR VPWR _0315_ sky130_fd_sc_hd__mux2_1
XFILLER_0_23_90 VGND VGND VPWR VPWR sky130_fd_sc_hd__decap_6
XFILLER_0_21_212 VGND VGND VPWR VPWR sky130_fd_sc_hd__fill_1
X_1011_ clknet_4_12_0_clk _0115_ VGND VGND VPWR VPWR memory\[5\]\[2\] sky130_fd_sc_hd__dfxtp_1
X_0726_ _0343_ VGND VGND VPWR VPWR _0084_ sky130_fd_sc_hd__clkbuf_1
XFILLER_0_33_3 VPWR VGND VPWR VGND sky130_ef_sc_hd__decap_12
X_0588_ net46 _0221_ _0241_ _0247_ _0236_ VGND VGND VPWR VPWR _0042_ sky130_fd_sc_hd__o221a_1
X_0657_ net65 net7 _0301_ VGND VGND VPWR VPWR _0306_ sky130_fd_sc_hd__mux2_1
XFILLER_0_39_109 VGND VGND VPWR VPWR sky130_fd_sc_hd__decap_3
XFILLER_0_38_197 VPWR VGND VPWR VGND sky130_ef_sc_hd__decap_12
XFILLER_0_38_153 VPWR VGND VPWR VGND sky130_ef_sc_hd__decap_12
XFILLER_0_14_15 VGND VGND VPWR VPWR sky130_fd_sc_hd__fill_1
X_0511_ _0193_ VGND VGND VPWR VPWR _0019_ sky130_fd_sc_hd__clkbuf_1
XTAP_204 VGND VPWR sky130_fd_sc_hd__tapvpwrvgnd_1
XTAP_215 VGND VPWR sky130_fd_sc_hd__tapvpwrvgnd_1
XTAP_226 VGND VPWR sky130_fd_sc_hd__tapvpwrvgnd_1
XTAP_237 VGND VPWR sky130_fd_sc_hd__tapvpwrvgnd_1
XTAP_248 VGND VPWR sky130_fd_sc_hd__tapvpwrvgnd_1
XTAP_259 VGND VPWR sky130_fd_sc_hd__tapvpwrvgnd_1
XFILLER_0_44_189 VGND VGND VPWR VPWR sky130_fd_sc_hd__decap_6
XFILLER_0_4_242 VGND VGND VPWR VPWR sky130_fd_sc_hd__decap_8
XFILLER_0_29_197 VGND VGND VPWR VPWR sky130_fd_sc_hd__decap_3
XFILLER_0_4_253 VPWR VGND VPWR VGND sky130_ef_sc_hd__decap_12
X_0709_ _0334_ VGND VGND VPWR VPWR _0076_ sky130_fd_sc_hd__clkbuf_1
X_0991_ clknet_4_0_0_clk _0095_ VGND VGND VPWR VPWR memory\[10\]\[6\] sky130_fd_sc_hd__dfxtp_1
XFILLER_0_26_123 VPWR VGND VPWR VGND sky130_ef_sc_hd__decap_12
XFILLER_0_1_223 VGND VGND VPWR VPWR sky130_fd_sc_hd__fill_1
XFILLER_0_5_57 VGND VGND VPWR VPWR sky130_fd_sc_hd__decap_8
XFILLER_0_49_237 VPWR VGND VPWR VGND sky130_ef_sc_hd__decap_12
XFILLER_0_17_134 VGND VGND VPWR VPWR sky130_fd_sc_hd__decap_8
XFILLER_0_23_126 VPWR VGND VPWR VGND sky130_ef_sc_hd__decap_12
XFILLER_0_31_181 VGND VGND VPWR VPWR sky130_fd_sc_hd__decap_6
XFILLER_0_31_192 VGND VGND VPWR VPWR sky130_fd_sc_hd__decap_8
Xinput9 wr_data[6] VGND VGND VPWR VPWR net9 sky130_fd_sc_hd__buf_2
XFILLER_0_39_281 VPWR VGND VPWR VGND sky130_ef_sc_hd__decap_12
X_0974_ clknet_4_0_0_clk _0078_ VGND VGND VPWR VPWR memory\[11\]\[5\] sky130_fd_sc_hd__dfxtp_1
XFILLER_0_22_170 VGND VGND VPWR VPWR sky130_fd_sc_hd__decap_8
XFILLER_0_45_273 VGND VGND VPWR VPWR sky130_fd_sc_hd__decap_6
XPHY_82 VGND VGND VPWR VPWR sky130_fd_sc_hd__decap_3
XPHY_71 VGND VGND VPWR VPWR sky130_fd_sc_hd__decap_3
XFILLER_0_22_15 VPWR VGND VPWR VGND sky130_ef_sc_hd__decap_12
XPHY_60 VGND VGND VPWR VPWR sky130_fd_sc_hd__decap_3
XFILLER_0_51_265 VPWR VGND VPWR VGND sky130_ef_sc_hd__decap_12
XFILLER_0_51_210 VPWR VGND VPWR VGND sky130_ef_sc_hd__decap_12
XPHY_93 VGND VGND VPWR VPWR sky130_fd_sc_hd__decap_3
XFILLER_0_36_262 VPWR VGND VPWR VGND sky130_ef_sc_hd__decap_12
XFILLER_0_36_251 VGND VGND VPWR VPWR sky130_fd_sc_hd__fill_1
Xclkbuf_4_6_0_clk clknet_0_clk VGND VGND VPWR VPWR clknet_4_6_0_clk sky130_fd_sc_hd__clkbuf_8
X_0690_ _0323_ VGND VGND VPWR VPWR _0068_ sky130_fd_sc_hd__clkbuf_1
XFILLER_0_27_262 VGND VGND VPWR VPWR sky130_fd_sc_hd__decap_4
X_0957_ clknet_4_15_0_clk _0061_ VGND VGND VPWR VPWR memory\[3\]\[4\] sky130_fd_sc_hd__dfxtp_1
X_0888_ data_count\[3\] data_count\[2\] VGND VGND VPWR VPWR _0440_ sky130_fd_sc_hd__or2_1
XFILLER_0_10_184 VPWR VGND VPWR VGND sky130_ef_sc_hd__decap_12
XFILLER_0_33_243 VGND VGND VPWR VPWR sky130_fd_sc_hd__fill_1
XFILLER_0_18_251 VGND VGND VPWR VPWR sky130_fd_sc_hd__fill_1
XFILLER_0_17_15 VGND VGND VPWR VPWR sky130_fd_sc_hd__decap_6
X_0673_ _0314_ VGND VGND VPWR VPWR _0060_ sky130_fd_sc_hd__clkbuf_1
X_0811_ _0389_ VGND VGND VPWR VPWR _0123_ sky130_fd_sc_hd__clkbuf_1
X_0742_ _0166_ net146 _0348_ VGND VGND VPWR VPWR _0352_ sky130_fd_sc_hd__mux2_1
XFILLER_0_24_298 VGND VGND VPWR VPWR sky130_fd_sc_hd__decap_8
XFILLER_0_15_210 VGND VGND VPWR VPWR sky130_fd_sc_hd__fill_2
XFILLER_0_15_221 VGND VGND VPWR VPWR sky130_fd_sc_hd__decap_3
XFILLER_0_30_213 VGND VGND VPWR VPWR sky130_fd_sc_hd__decap_8
X_1010_ clknet_4_13_0_clk _0114_ VGND VGND VPWR VPWR memory\[5\]\[1\] sky130_fd_sc_hd__dfxtp_1
X_0656_ _0305_ VGND VGND VPWR VPWR _0052_ sky130_fd_sc_hd__clkbuf_1
X_0725_ _0166_ net86 _0339_ VGND VGND VPWR VPWR _0343_ sky130_fd_sc_hd__mux2_1
X_0587_ _0222_ _0246_ _0229_ VGND VGND VPWR VPWR _0247_ sky130_fd_sc_hd__a21o_1
XFILLER_0_38_165 VPWR VGND VPWR VGND sky130_ef_sc_hd__decap_12
XFILLER_0_39_57 VGND VGND VPWR VPWR sky130_fd_sc_hd__decap_8
X_0510_ _0164_ net103 _0190_ VGND VGND VPWR VPWR _0193_ sky130_fd_sc_hd__mux2_1
XTAP_205 VGND VPWR sky130_fd_sc_hd__tapvpwrvgnd_1
XTAP_216 VGND VPWR sky130_fd_sc_hd__tapvpwrvgnd_1
XTAP_227 VGND VPWR sky130_fd_sc_hd__tapvpwrvgnd_1
XTAP_238 VGND VPWR sky130_fd_sc_hd__tapvpwrvgnd_1
Xhold1 write_pointer\[0\] VGND VGND VPWR VPWR net26 sky130_fd_sc_hd__dlygate4sd3_1
XTAP_249 VGND VPWR sky130_fd_sc_hd__tapvpwrvgnd_1
XFILLER_0_29_121 VGND VGND VPWR VPWR sky130_fd_sc_hd__fill_2
XFILLER_0_4_265 VPWR VGND VPWR VGND sky130_ef_sc_hd__decap_12
XFILLER_0_17_305 VGND VGND VPWR VPWR sky130_fd_sc_hd__fill_2
X_0639_ memory\[12\]\[7\] memory\[13\]\[7\] memory\[14\]\[7\] memory\[15\]\[7\] _0223_
+ _0224_ VGND VGND VPWR VPWR _0293_ sky130_fd_sc_hd__mux4_1
X_0708_ net51 net6 _0330_ VGND VGND VPWR VPWR _0334_ sky130_fd_sc_hd__mux2_1
XFILLER_0_35_113 VGND VGND VPWR VPWR sky130_fd_sc_hd__fill_1
XFILLER_0_50_105 VGND VGND VPWR VPWR sky130_fd_sc_hd__fill_1
X_0990_ clknet_4_0_0_clk _0094_ VGND VGND VPWR VPWR memory\[10\]\[5\] sky130_fd_sc_hd__dfxtp_1
XFILLER_0_26_135 VGND VGND VPWR VPWR sky130_fd_sc_hd__decap_4
XFILLER_0_26_179 VGND VGND VPWR VPWR sky130_fd_sc_hd__fill_1
XFILLER_0_34_190 VGND VGND VPWR VPWR sky130_fd_sc_hd__decap_6
XFILLER_0_1_279 VGND VGND VPWR VPWR sky130_fd_sc_hd__fill_1
XFILLER_0_49_249 VPWR VGND VPWR VGND sky130_ef_sc_hd__decap_12
XFILLER_0_32_149 VGND VGND VPWR VPWR sky130_fd_sc_hd__decap_3
XFILLER_0_23_138 VGND VGND VPWR VPWR sky130_fd_sc_hd__fill_2
XFILLER_0_39_293 VPWR VGND VPWR VGND sky130_ef_sc_hd__decap_12
XFILLER_0_39_260 VPWR VGND VPWR VGND sky130_ef_sc_hd__decap_12
XFILLER_0_14_116 VPWR VGND VPWR VGND sky130_ef_sc_hd__decap_12
X_0973_ clknet_4_11_0_clk _0077_ VGND VGND VPWR VPWR memory\[11\]\[4\] sky130_fd_sc_hd__dfxtp_1
XFILLER_0_9_110 VGND VGND VPWR VPWR sky130_fd_sc_hd__fill_2
XPHY_94 VGND VGND VPWR VPWR sky130_fd_sc_hd__decap_3
XPHY_83 VGND VGND VPWR VPWR sky130_fd_sc_hd__decap_3
XPHY_72 VGND VGND VPWR VPWR sky130_fd_sc_hd__decap_3
XFILLER_0_22_27 VGND VGND VPWR VPWR sky130_fd_sc_hd__fill_1
XPHY_50 VGND VGND VPWR VPWR sky130_fd_sc_hd__decap_3
XPHY_61 VGND VGND VPWR VPWR sky130_fd_sc_hd__decap_3
XFILLER_0_51_277 VGND VGND VPWR VPWR sky130_fd_sc_hd__decap_3
XFILLER_0_51_222 VGND VGND VPWR VPWR sky130_fd_sc_hd__fill_2
XFILLER_0_36_274 VPWR VGND VPWR VGND sky130_ef_sc_hd__decap_12
XFILLER_0_11_108 VGND VGND VPWR VPWR sky130_fd_sc_hd__decap_4
XFILLER_0_47_57 VGND VGND VPWR VPWR sky130_fd_sc_hd__fill_1
XFILLER_0_2_15 VPWR VGND VPWR VGND sky130_ef_sc_hd__decap_12
X_0956_ clknet_4_7_0_clk _0060_ VGND VGND VPWR VPWR memory\[3\]\[3\] sky130_fd_sc_hd__dfxtp_1
X_0887_ _0438_ _0439_ VGND VGND VPWR VPWR _0149_ sky130_fd_sc_hd__nor2_1
XFILLER_0_33_211 VPWR VGND VPWR VGND sky130_ef_sc_hd__decap_12
XFILLER_0_33_15 VPWR VGND VPWR VGND sky130_ef_sc_hd__decap_12
XFILLER_0_17_38 VGND VGND VPWR VPWR sky130_fd_sc_hd__decap_6
X_0810_ net33 net5 _0386_ VGND VGND VPWR VPWR _0389_ sky130_fd_sc_hd__mux2_1
X_0672_ net101 net6 _0310_ VGND VGND VPWR VPWR _0314_ sky130_fd_sc_hd__mux2_1
X_0741_ _0351_ VGND VGND VPWR VPWR _0091_ sky130_fd_sc_hd__clkbuf_1
XFILLER_0_3_116 VGND VGND VPWR VPWR sky130_fd_sc_hd__fill_1
XFILLER_0_15_277 VGND VGND VPWR VPWR sky130_fd_sc_hd__decap_3
X_0939_ clknet_4_11_0_clk _0043_ VGND VGND VPWR VPWR net17 sky130_fd_sc_hd__dfxtp_1
XFILLER_0_30_269 VGND VGND VPWR VPWR sky130_fd_sc_hd__fill_1
Xclkbuf_4_5_0_clk clknet_0_clk VGND VGND VPWR VPWR clknet_4_5_0_clk sky130_fd_sc_hd__clkbuf_8
XFILLER_0_21_225 VGND VGND VPWR VPWR sky130_fd_sc_hd__decap_3
XFILLER_0_21_236 VPWR VGND VPWR VGND sky130_ef_sc_hd__decap_12
XFILLER_0_28_15 VPWR VGND VPWR VGND sky130_ef_sc_hd__decap_12
XFILLER_0_8_208 VPWR VGND VPWR VGND sky130_ef_sc_hd__decap_12
XFILLER_0_29_303 VGND VGND VPWR VPWR sky130_fd_sc_hd__decap_4
X_0724_ _0342_ VGND VGND VPWR VPWR _0083_ sky130_fd_sc_hd__clkbuf_1
X_0586_ _0244_ _0245_ _0227_ VGND VGND VPWR VPWR _0246_ sky130_fd_sc_hd__mux2_1
XFILLER_0_20_291 VPWR VGND VPWR VGND sky130_ef_sc_hd__decap_12
X_0655_ net107 net6 _0301_ VGND VGND VPWR VPWR _0305_ sky130_fd_sc_hd__mux2_1
XFILLER_0_14_39 VPWR VGND VPWR VGND sky130_ef_sc_hd__decap_12
XFILLER_0_38_177 VGND VGND VPWR VPWR sky130_fd_sc_hd__decap_4
XFILLER_0_30_38 VGND VGND VPWR VPWR sky130_fd_sc_hd__fill_2
XTAP_206 VGND VPWR sky130_fd_sc_hd__tapvpwrvgnd_1
XTAP_217 VGND VPWR sky130_fd_sc_hd__tapvpwrvgnd_1
XTAP_228 VGND VPWR sky130_fd_sc_hd__tapvpwrvgnd_1
XTAP_239 VGND VPWR sky130_fd_sc_hd__tapvpwrvgnd_1
Xhold2 write_pointer\[1\] VGND VGND VPWR VPWR net27 sky130_fd_sc_hd__dlygate4sd3_1
XFILLER_0_29_111 VGND VGND VPWR VPWR sky130_fd_sc_hd__fill_1
XFILLER_0_29_177 VGND VGND VPWR VPWR sky130_fd_sc_hd__decap_6
XFILLER_0_4_277 VPWR VGND VPWR VGND sky130_ef_sc_hd__decap_12
X_0707_ _0333_ VGND VGND VPWR VPWR _0075_ sky130_fd_sc_hd__clkbuf_1
X_0569_ _0222_ _0228_ _0229_ VGND VGND VPWR VPWR _0230_ sky130_fd_sc_hd__a21o_1
X_0638_ memory\[8\]\[7\] memory\[9\]\[7\] memory\[10\]\[7\] memory\[11\]\[7\] _0223_
+ _0243_ VGND VGND VPWR VPWR _0292_ sky130_fd_sc_hd__mux4_1
XFILLER_0_35_169 VGND VGND VPWR VPWR sky130_fd_sc_hd__fill_1
XFILLER_0_0_81 VGND VGND VPWR VPWR sky130_fd_sc_hd__decap_3
XFILLER_0_43_180 VGND VGND VPWR VPWR sky130_fd_sc_hd__decap_6
XFILLER_0_8_3 VPWR VGND VPWR VGND sky130_ef_sc_hd__decap_12
XFILLER_0_41_15 VGND VGND VPWR VPWR sky130_fd_sc_hd__decap_4
XFILLER_0_1_225 VPWR VGND VPWR VGND sky130_ef_sc_hd__decap_12
XFILLER_0_26_114 VGND VGND VPWR VPWR sky130_fd_sc_hd__fill_1
XFILLER_0_26_169 VGND VGND VPWR VPWR sky130_fd_sc_hd__decap_6
XFILLER_0_5_15 VGND VGND VPWR VPWR sky130_fd_sc_hd__decap_4
XFILLER_0_25_191 VPWR VGND VPWR VGND sky130_ef_sc_hd__decap_12
XFILLER_0_39_272 VGND VGND VPWR VPWR sky130_fd_sc_hd__decap_8
X_0972_ clknet_4_6_0_clk _0076_ VGND VGND VPWR VPWR memory\[11\]\[3\] sky130_fd_sc_hd__dfxtp_1
XFILLER_0_14_128 VPWR VGND VPWR VGND sky130_ef_sc_hd__decap_12
XFILLER_0_9_199 VGND VGND VPWR VPWR sky130_fd_sc_hd__fill_1
XFILLER_0_13_161 VGND VGND VPWR VPWR sky130_fd_sc_hd__decap_6
XPHY_95 VGND VGND VPWR VPWR sky130_fd_sc_hd__decap_3
XPHY_84 VGND VGND VPWR VPWR sky130_fd_sc_hd__decap_3
XPHY_73 VGND VGND VPWR VPWR sky130_fd_sc_hd__decap_3
XPHY_40 VGND VGND VPWR VPWR sky130_fd_sc_hd__decap_3
XPHY_51 VGND VGND VPWR VPWR sky130_fd_sc_hd__decap_3
XPHY_62 VGND VGND VPWR VPWR sky130_fd_sc_hd__decap_3
XFILLER_0_36_286 VGND VGND VPWR VPWR sky130_fd_sc_hd__fill_2
XFILLER_0_2_27 VGND VGND VPWR VPWR sky130_fd_sc_hd__fill_1
XFILLER_0_42_223 VGND VGND VPWR VPWR sky130_fd_sc_hd__decap_6
X_0955_ clknet_4_15_0_clk _0059_ VGND VGND VPWR VPWR memory\[3\]\[2\] sky130_fd_sc_hd__dfxtp_1
XFILLER_0_6_147 VGND VGND VPWR VPWR sky130_fd_sc_hd__fill_1
XFILLER_0_12_50 VGND VGND VPWR VPWR sky130_fd_sc_hd__fill_2
X_0886_ _0432_ _0433_ _0437_ _0296_ VGND VGND VPWR VPWR _0439_ sky130_fd_sc_hd__a31o_1
XFILLER_0_49_3 VPWR VGND VPWR VGND sky130_ef_sc_hd__decap_12
XFILLER_0_10_197 VGND VGND VPWR VPWR sky130_fd_sc_hd__fill_1
XFILLER_0_33_223 VGND VGND VPWR VPWR sky130_fd_sc_hd__fill_1
XFILLER_0_33_27 VPWR VGND VPWR VGND sky130_ef_sc_hd__decap_12
X_0740_ _0164_ net73 _0348_ VGND VGND VPWR VPWR _0351_ sky130_fd_sc_hd__mux2_1
X_0671_ _0313_ VGND VGND VPWR VPWR _0059_ sky130_fd_sc_hd__clkbuf_1
X_0938_ clknet_4_10_0_clk _0042_ VGND VGND VPWR VPWR net16 sky130_fd_sc_hd__dfxtp_1
X_0869_ _0297_ _0220_ data_count\[1\] VGND VGND VPWR VPWR _0424_ sky130_fd_sc_hd__a21o_1
XFILLER_0_3_81 VPWR VGND VPWR VGND sky130_ef_sc_hd__decap_12
XFILLER_0_21_248 VPWR VGND VPWR VGND sky130_ef_sc_hd__decap_12
XFILLER_0_44_15 VPWR VGND VPWR VGND sky130_ef_sc_hd__decap_12
XFILLER_0_28_27 VGND VGND VPWR VPWR sky130_fd_sc_hd__fill_1
XFILLER_0_8_37 VPWR VGND VPWR VGND sky130_ef_sc_hd__decap_12
XFILLER_0_8_15 VPWR VGND VPWR VGND sky130_ef_sc_hd__decap_12
X_0723_ _0164_ net131 _0339_ VGND VGND VPWR VPWR _0342_ sky130_fd_sc_hd__mux2_1
X_0585_ memory\[12\]\[1\] memory\[13\]\[1\] memory\[14\]\[1\] memory\[15\]\[1\] _0223_
+ _0243_ VGND VGND VPWR VPWR _0245_ sky130_fd_sc_hd__mux4_1
X_0654_ _0304_ VGND VGND VPWR VPWR _0051_ sky130_fd_sc_hd__clkbuf_1
XFILLER_0_47_167 VGND VGND VPWR VPWR sky130_fd_sc_hd__fill_1
XFILLER_0_11_281 VPWR VGND VPWR VGND sky130_ef_sc_hd__decap_12
XFILLER_0_38_101 VGND VGND VPWR VPWR sky130_fd_sc_hd__decap_4
XFILLER_0_14_29 VGND VGND VPWR VPWR sky130_fd_sc_hd__fill_2
XFILLER_0_39_15 VPWR VGND VPWR VGND sky130_ef_sc_hd__decap_12
XTAP_207 VGND VPWR sky130_fd_sc_hd__tapvpwrvgnd_1
XTAP_218 VGND VPWR sky130_fd_sc_hd__tapvpwrvgnd_1
XTAP_229 VGND VPWR sky130_fd_sc_hd__tapvpwrvgnd_1
Xhold3 memory\[11\]\[2\] VGND VGND VPWR VPWR net28 sky130_fd_sc_hd__dlygate4sd3_1
XFILLER_0_29_189 VGND VGND VPWR VPWR sky130_fd_sc_hd__decap_8
Xclkbuf_4_4_0_clk clknet_0_clk VGND VGND VPWR VPWR clknet_4_4_0_clk sky130_fd_sc_hd__clkbuf_8
XFILLER_0_4_289 VPWR VGND VPWR VGND sky130_ef_sc_hd__decap_12
X_0706_ net28 net5 _0330_ VGND VGND VPWR VPWR _0333_ sky130_fd_sc_hd__mux2_1
XFILLER_0_20_83 VGND VGND VPWR VPWR sky130_fd_sc_hd__fill_1
X_0499_ _0172_ net126 _0179_ VGND VGND VPWR VPWR _0186_ sky130_fd_sc_hd__mux2_1
X_0637_ read_pointer\[3\] _0290_ VGND VGND VPWR VPWR _0291_ sky130_fd_sc_hd__and2b_1
X_0568_ data_count\[4\] _0151_ net1 VGND VGND VPWR VPWR _0229_ sky130_fd_sc_hd__o21ai_4
XFILLER_0_31_3 VPWR VGND VPWR VGND sky130_ef_sc_hd__decap_12
XFILLER_0_1_215 VGND VGND VPWR VPWR sky130_fd_sc_hd__decap_8
XFILLER_0_1_237 VPWR VGND VPWR VGND sky130_ef_sc_hd__decap_12
XFILLER_0_17_148 VGND VGND VPWR VPWR sky130_fd_sc_hd__fill_2
XFILLER_0_40_195 VGND VGND VPWR VPWR sky130_fd_sc_hd__fill_1
XFILLER_0_40_184 VGND VGND VPWR VPWR sky130_fd_sc_hd__fill_2
XFILLER_0_0_281 VPWR VGND VPWR VGND sky130_ef_sc_hd__decap_12
XFILLER_0_25_181 VGND VGND VPWR VPWR sky130_fd_sc_hd__fill_1
XFILLER_0_48_251 VGND VGND VPWR VPWR sky130_fd_sc_hd__fill_1
XFILLER_0_36_38 VGND VGND VPWR VPWR sky130_fd_sc_hd__fill_1
X_0971_ clknet_4_10_0_clk _0075_ VGND VGND VPWR VPWR memory\[11\]\[2\] sky130_fd_sc_hd__dfxtp_1
XFILLER_0_22_195 VGND VGND VPWR VPWR sky130_fd_sc_hd__fill_1
XFILLER_0_26_60 VPWR VGND VPWR VGND sky130_ef_sc_hd__decap_12
XFILLER_0_9_156 VPWR VGND VPWR VGND sky130_ef_sc_hd__decap_12
XFILLER_0_42_81 VGND VGND VPWR VPWR sky130_fd_sc_hd__decap_3
XPHY_30 VGND VGND VPWR VPWR sky130_fd_sc_hd__decap_3
XPHY_96 VGND VGND VPWR VPWR sky130_fd_sc_hd__decap_3
XPHY_85 VGND VGND VPWR VPWR sky130_fd_sc_hd__decap_3
XPHY_74 VGND VGND VPWR VPWR sky130_fd_sc_hd__decap_3
XPHY_41 VGND VGND VPWR VPWR sky130_fd_sc_hd__decap_3
XFILLER_0_22_29 VPWR VGND VPWR VGND sky130_ef_sc_hd__decap_12
XPHY_52 VGND VGND VPWR VPWR sky130_fd_sc_hd__decap_3
XPHY_63 VGND VGND VPWR VPWR sky130_fd_sc_hd__decap_3
XFILLER_0_47_15 VPWR VGND VPWR VGND sky130_ef_sc_hd__decap_12
X_0954_ clknet_4_13_0_clk _0058_ VGND VGND VPWR VPWR memory\[3\]\[1\] sky130_fd_sc_hd__dfxtp_1
X_0885_ _0432_ _0433_ _0437_ VGND VGND VPWR VPWR _0438_ sky130_fd_sc_hd__a21oi_1
XFILLER_0_33_39 VPWR VGND VPWR VGND sky130_ef_sc_hd__decap_12
X_0670_ net44 net5 _0310_ VGND VGND VPWR VPWR _0313_ sky130_fd_sc_hd__mux2_1
XFILLER_0_24_224 VPWR VGND VPWR VGND sky130_ef_sc_hd__decap_12
XFILLER_0_47_305 VGND VGND VPWR VPWR sky130_fd_sc_hd__fill_2
XFILLER_0_15_202 VGND VGND VPWR VPWR sky130_fd_sc_hd__decap_8
XFILLER_0_15_257 VPWR VGND VPWR VGND sky130_ef_sc_hd__decap_12
X_0937_ clknet_4_3_0_clk _0041_ VGND VGND VPWR VPWR net15 sky130_fd_sc_hd__dfxtp_1
X_0868_ net11 net1 data_count\[1\] VGND VGND VPWR VPWR _0423_ sky130_fd_sc_hd__and3b_1
X_0799_ _0382_ VGND VGND VPWR VPWR _0118_ sky130_fd_sc_hd__clkbuf_1
XFILLER_0_30_249 VGND VGND VPWR VPWR sky130_fd_sc_hd__decap_3
XFILLER_0_38_305 VGND VGND VPWR VPWR sky130_fd_sc_hd__fill_2
XFILLER_0_44_27 VGND VGND VPWR VPWR sky130_fd_sc_hd__fill_1
XFILLER_0_8_49 VGND VGND VPWR VPWR sky130_fd_sc_hd__decap_3
XFILLER_0_8_27 VGND VGND VPWR VPWR sky130_fd_sc_hd__fill_1
X_0653_ net74 net5 _0301_ VGND VGND VPWR VPWR _0304_ sky130_fd_sc_hd__mux2_1
XFILLER_0_12_249 VGND VGND VPWR VPWR sky130_fd_sc_hd__decap_3
X_0722_ _0341_ VGND VGND VPWR VPWR _0082_ sky130_fd_sc_hd__clkbuf_1
X_0584_ memory\[8\]\[1\] memory\[9\]\[1\] memory\[10\]\[1\] memory\[11\]\[1\] _0242_
+ _0243_ VGND VGND VPWR VPWR _0244_ sky130_fd_sc_hd__mux4_1
XFILLER_0_7_221 VGND VGND VPWR VPWR sky130_fd_sc_hd__decap_3
XFILLER_0_11_293 VPWR VGND VPWR VGND sky130_ef_sc_hd__decap_12
Xhold4 memory\[3\]\[4\] VGND VGND VPWR VPWR net29 sky130_fd_sc_hd__dlygate4sd3_1
XFILLER_0_39_27 VPWR VGND VPWR VGND sky130_ef_sc_hd__decap_12
XTAP_208 VGND VPWR sky130_fd_sc_hd__tapvpwrvgnd_1
XTAP_219 VGND VPWR sky130_fd_sc_hd__tapvpwrvgnd_1
XFILLER_0_44_138 VGND VGND VPWR VPWR sky130_fd_sc_hd__fill_2
XFILLER_0_29_113 VGND VGND VPWR VPWR sky130_fd_sc_hd__decap_8
X_0636_ _0288_ _0289_ read_pointer\[2\] VGND VGND VPWR VPWR _0290_ sky130_fd_sc_hd__mux2_1
X_0705_ _0332_ VGND VGND VPWR VPWR _0074_ sky130_fd_sc_hd__clkbuf_1
X_0498_ _0185_ VGND VGND VPWR VPWR _0014_ sky130_fd_sc_hd__clkbuf_1
X_0567_ _0225_ _0226_ _0227_ VGND VGND VPWR VPWR _0228_ sky130_fd_sc_hd__mux2_1
XFILLER_0_24_3 VGND VGND VPWR VPWR sky130_fd_sc_hd__decap_4
XFILLER_0_28_190 VGND VGND VPWR VPWR sky130_fd_sc_hd__decap_6
XFILLER_0_1_249 VPWR VGND VPWR VGND sky130_ef_sc_hd__decap_12
XFILLER_0_9_305 VGND VGND VPWR VPWR sky130_fd_sc_hd__fill_2
XFILLER_0_15_84 VGND VGND VPWR VPWR sky130_fd_sc_hd__fill_2
XFILLER_0_40_130 VGND VGND VPWR VPWR sky130_fd_sc_hd__decap_8
XFILLER_0_0_293 VGND VGND VPWR VPWR sky130_fd_sc_hd__decap_8
X_0619_ read_pointer\[3\] _0274_ VGND VGND VPWR VPWR _0275_ sky130_fd_sc_hd__and2b_1
XFILLER_0_16_182 VPWR VGND VPWR VGND sky130_ef_sc_hd__decap_12
Xclkbuf_4_3_0_clk clknet_0_clk VGND VGND VPWR VPWR clknet_4_3_0_clk sky130_fd_sc_hd__clkbuf_8
X_0970_ clknet_4_8_0_clk _0074_ VGND VGND VPWR VPWR memory\[11\]\[1\] sky130_fd_sc_hd__dfxtp_1
XFILLER_0_22_141 VGND VGND VPWR VPWR sky130_fd_sc_hd__decap_4
XFILLER_0_26_72 VGND VGND VPWR VPWR sky130_fd_sc_hd__decap_4
XFILLER_0_26_83 VGND VGND VPWR VPWR sky130_fd_sc_hd__fill_1
XPHY_20 VGND VGND VPWR VPWR sky130_fd_sc_hd__decap_3
XPHY_31 VGND VGND VPWR VPWR sky130_fd_sc_hd__decap_3
XPHY_42 VGND VGND VPWR VPWR sky130_fd_sc_hd__decap_3
XPHY_53 VGND VGND VPWR VPWR sky130_fd_sc_hd__decap_3
XPHY_64 VGND VGND VPWR VPWR sky130_fd_sc_hd__decap_3
XFILLER_0_51_225 VPWR VGND VPWR VGND sky130_ef_sc_hd__decap_12
XPHY_97 VGND VGND VPWR VPWR sky130_fd_sc_hd__decap_3
XPHY_86 VGND VGND VPWR VPWR sky130_fd_sc_hd__decap_3
XPHY_75 VGND VGND VPWR VPWR sky130_fd_sc_hd__decap_3
XFILLER_0_36_200 VGND VGND VPWR VPWR sky130_fd_sc_hd__fill_2
XFILLER_0_47_27 VPWR VGND VPWR VGND sky130_ef_sc_hd__decap_12
XFILLER_0_2_29 VPWR VGND VPWR VGND sky130_ef_sc_hd__decap_12
X_0953_ clknet_4_6_0_clk _0057_ VGND VGND VPWR VPWR memory\[3\]\[0\] sky130_fd_sc_hd__dfxtp_1
XFILLER_0_12_85 VGND VGND VPWR VPWR sky130_fd_sc_hd__decap_4
X_0884_ _0435_ _0436_ VGND VGND VPWR VPWR _0437_ sky130_fd_sc_hd__or2_1
XFILLER_0_27_277 VGND VGND VPWR VPWR sky130_fd_sc_hd__decap_3
XFILLER_0_33_225 VPWR VGND VPWR VGND sky130_ef_sc_hd__decap_12
XFILLER_0_18_288 VPWR VGND VPWR VGND sky130_ef_sc_hd__decap_12
XFILLER_0_24_236 VPWR VGND VPWR VGND sky130_ef_sc_hd__decap_12
X_0936_ clknet_4_5_0_clk _0040_ VGND VGND VPWR VPWR memory\[1\]\[7\] sky130_fd_sc_hd__dfxtp_1
XFILLER_0_15_225 VGND VGND VPWR VPWR sky130_fd_sc_hd__fill_2
XFILLER_0_2_141 VPWR VGND VPWR VGND sky130_ef_sc_hd__decap_12
XFILLER_0_15_269 VGND VGND VPWR VPWR sky130_fd_sc_hd__decap_8
X_0798_ _0170_ net112 _0376_ VGND VGND VPWR VPWR _0382_ sky130_fd_sc_hd__mux2_1
X_0867_ _0422_ VGND VGND VPWR VPWR _0146_ sky130_fd_sc_hd__clkbuf_1
XFILLER_0_28_29 VPWR VGND VPWR VGND sky130_ef_sc_hd__decap_12
X_0652_ _0303_ VGND VGND VPWR VPWR _0050_ sky130_fd_sc_hd__clkbuf_1
XFILLER_0_12_217 VPWR VGND VPWR VGND sky130_ef_sc_hd__decap_12
X_0721_ _0162_ net53 _0339_ VGND VGND VPWR VPWR _0341_ sky130_fd_sc_hd__mux2_1
X_0583_ read_pointer\[1\] VGND VGND VPWR VPWR _0243_ sky130_fd_sc_hd__clkbuf_4
XFILLER_0_18_51 VGND VGND VPWR VPWR sky130_fd_sc_hd__fill_1
XFILLER_0_20_261 VGND VGND VPWR VPWR sky130_fd_sc_hd__fill_1
XFILLER_0_20_283 VGND VGND VPWR VPWR sky130_fd_sc_hd__fill_1
XFILLER_0_34_83 VGND VGND VPWR VPWR sky130_fd_sc_hd__fill_1
XFILLER_0_50_93 VPWR VGND VPWR VGND sky130_ef_sc_hd__decap_12
XFILLER_0_7_244 VPWR VGND VPWR VGND sky130_ef_sc_hd__decap_12
X_0919_ clknet_4_0_0_clk _0023_ VGND VGND VPWR VPWR memory\[13\]\[6\] sky130_fd_sc_hd__dfxtp_1
XFILLER_0_39_39 VPWR VGND VPWR VGND sky130_ef_sc_hd__decap_12
Xhold5 memory\[7\]\[2\] VGND VGND VPWR VPWR net30 sky130_fd_sc_hd__dlygate4sd3_1
XTAP_209 VGND VPWR sky130_fd_sc_hd__tapvpwrvgnd_1
XFILLER_0_40_301 VGND VGND VPWR VPWR sky130_fd_sc_hd__decap_6
X_0635_ memory\[4\]\[7\] memory\[5\]\[7\] memory\[6\]\[7\] memory\[7\]\[7\] read_pointer\[0\]
+ read_pointer\[1\] VGND VGND VPWR VPWR _0289_ sky130_fd_sc_hd__mux4_1
X_0704_ net54 net4 _0330_ VGND VGND VPWR VPWR _0332_ sky130_fd_sc_hd__mux2_1
X_0566_ read_pointer\[2\] VGND VGND VPWR VPWR _0227_ sky130_fd_sc_hd__clkbuf_4
X_0497_ _0170_ net79 _0179_ VGND VGND VPWR VPWR _0185_ sky130_fd_sc_hd__mux2_1
XFILLER_0_17_3 VPWR VGND VPWR VGND sky130_ef_sc_hd__decap_12
XFILLER_0_43_150 VGND VGND VPWR VPWR sky130_fd_sc_hd__decap_6
XFILLER_0_26_139 VGND VGND VPWR VPWR sky130_fd_sc_hd__fill_1
X_0549_ _0166_ net150 _0211_ VGND VGND VPWR VPWR _0215_ sky130_fd_sc_hd__mux2_1
X_0618_ _0272_ _0273_ read_pointer\[2\] VGND VGND VPWR VPWR _0274_ sky130_fd_sc_hd__mux2_1
XFILLER_0_48_253 VPWR VGND VPWR VGND sky130_ef_sc_hd__decap_12
XFILLER_0_16_194 VGND VGND VPWR VPWR sky130_fd_sc_hd__fill_2
XFILLER_0_10_304 VGND VGND VPWR VPWR sky130_fd_sc_hd__decap_3
XFILLER_0_22_197 VGND VGND VPWR VPWR sky130_fd_sc_hd__fill_2
XFILLER_0_9_169 VPWR VGND VPWR VGND sky130_ef_sc_hd__decap_12
XTAP_370 VGND VPWR sky130_fd_sc_hd__tapvpwrvgnd_1
XPHY_98 VGND VGND VPWR VPWR sky130_fd_sc_hd__decap_3
XPHY_87 VGND VGND VPWR VPWR sky130_fd_sc_hd__decap_3
XPHY_76 VGND VGND VPWR VPWR sky130_fd_sc_hd__decap_3
XPHY_65 VGND VGND VPWR VPWR sky130_fd_sc_hd__decap_3
XPHY_10 VGND VGND VPWR VPWR sky130_fd_sc_hd__decap_3
XPHY_21 VGND VGND VPWR VPWR sky130_fd_sc_hd__decap_3
XPHY_32 VGND VGND VPWR VPWR sky130_fd_sc_hd__decap_3
XPHY_43 VGND VGND VPWR VPWR sky130_fd_sc_hd__decap_3
XPHY_54 VGND VGND VPWR VPWR sky130_fd_sc_hd__decap_3
XFILLER_0_51_237 VPWR VGND VPWR VGND sky130_ef_sc_hd__decap_12
XFILLER_0_47_39 VPWR VGND VPWR VGND sky130_ef_sc_hd__decap_12
XFILLER_0_6_139 VGND VGND VPWR VPWR sky130_fd_sc_hd__fill_1
X_0952_ clknet_4_1_0_clk _0056_ VGND VGND VPWR VPWR memory\[12\]\[7\] sky130_fd_sc_hd__dfxtp_1
XFILLER_0_27_223 VGND VGND VPWR VPWR sky130_fd_sc_hd__fill_1
XFILLER_0_2_301 VGND VGND VPWR VPWR sky130_fd_sc_hd__decap_6
XFILLER_0_10_101 VGND VGND VPWR VPWR sky130_fd_sc_hd__fill_1
X_0883_ _0434_ _0297_ _0220_ VGND VGND VPWR VPWR _0436_ sky130_fd_sc_hd__and3_1
XFILLER_0_33_237 VGND VGND VPWR VPWR sky130_fd_sc_hd__decap_6
XFILLER_0_33_204 VGND VGND VPWR VPWR sky130_fd_sc_hd__fill_1
Xclkbuf_4_2_0_clk clknet_0_clk VGND VGND VPWR VPWR clknet_4_2_0_clk sky130_fd_sc_hd__clkbuf_8
XFILLER_0_18_245 VGND VGND VPWR VPWR sky130_fd_sc_hd__decap_6
XFILLER_0_41_281 VPWR VGND VPWR VGND sky130_ef_sc_hd__decap_12
XFILLER_0_32_281 VPWR VGND VPWR VGND sky130_ef_sc_hd__decap_12
XFILLER_0_24_248 VGND VGND VPWR VPWR sky130_fd_sc_hd__decap_4
X_0935_ clknet_4_5_0_clk _0039_ VGND VGND VPWR VPWR memory\[1\]\[6\] sky130_fd_sc_hd__dfxtp_1
XFILLER_0_23_96 VGND VGND VPWR VPWR sky130_fd_sc_hd__fill_1
X_0866_ _0155_ _0420_ _0421_ VGND VGND VPWR VPWR _0422_ sky130_fd_sc_hd__and3_1
X_0797_ _0381_ VGND VGND VPWR VPWR _0117_ sky130_fd_sc_hd__clkbuf_1
XFILLER_0_2_153 VGND VGND VPWR VPWR sky130_fd_sc_hd__decap_6
XFILLER_0_47_3 VPWR VGND VPWR VGND sky130_ef_sc_hd__decap_12
XFILLER_0_3_40 VPWR VGND VPWR VGND sky130_ef_sc_hd__decap_12
X_0720_ _0340_ VGND VGND VPWR VPWR _0081_ sky130_fd_sc_hd__clkbuf_1
X_0651_ net71 net4 _0301_ VGND VGND VPWR VPWR _0303_ sky130_fd_sc_hd__mux2_1
XFILLER_0_12_229 VGND VGND VPWR VPWR sky130_fd_sc_hd__decap_4
XFILLER_0_20_251 VGND VGND VPWR VPWR sky130_fd_sc_hd__fill_1
X_0582_ read_pointer\[0\] VGND VGND VPWR VPWR _0242_ sky130_fd_sc_hd__buf_4
XFILLER_0_18_85 VPWR VGND VPWR VGND sky130_ef_sc_hd__decap_12
X_0849_ write_pointer\[3\] _0407_ VGND VGND VPWR VPWR _0410_ sky130_fd_sc_hd__xor2_1
XFILLER_0_7_256 VPWR VGND VPWR VGND sky130_ef_sc_hd__decap_12
X_0918_ clknet_4_0_0_clk _0022_ VGND VGND VPWR VPWR memory\[13\]\[5\] sky130_fd_sc_hd__dfxtp_1
Xhold6 memory\[0\]\[1\] VGND VGND VPWR VPWR net31 sky130_fd_sc_hd__dlygate4sd3_1
XFILLER_0_29_148 VGND VGND VPWR VPWR sky130_fd_sc_hd__fill_1
XFILLER_0_44_107 VGND VGND VPWR VPWR sky130_fd_sc_hd__decap_6
X_0703_ _0331_ VGND VGND VPWR VPWR _0073_ sky130_fd_sc_hd__clkbuf_1
X_0634_ memory\[0\]\[7\] memory\[1\]\[7\] memory\[2\]\[7\] memory\[3\]\[7\] _0231_
+ _0237_ VGND VGND VPWR VPWR _0288_ sky130_fd_sc_hd__mux4_1
X_0496_ _0184_ VGND VGND VPWR VPWR _0013_ sky130_fd_sc_hd__clkbuf_1
X_0565_ memory\[12\]\[0\] memory\[13\]\[0\] memory\[14\]\[0\] memory\[15\]\[0\] _0223_
+ _0224_ VGND VGND VPWR VPWR _0226_ sky130_fd_sc_hd__mux4_1
XFILLER_0_45_61 VGND VGND VPWR VPWR sky130_fd_sc_hd__fill_1
XFILLER_0_0_41 VGND VGND VPWR VPWR sky130_fd_sc_hd__decap_4
XFILLER_0_0_85 VPWR VGND VPWR VGND sky130_ef_sc_hd__decap_12
XFILLER_0_3_281 VPWR VGND VPWR VGND sky130_ef_sc_hd__decap_12
XFILLER_0_41_19 VGND VGND VPWR VPWR sky130_fd_sc_hd__fill_1
XFILLER_0_34_162 VPWR VGND VPWR VGND sky130_ef_sc_hd__decap_12
XFILLER_0_19_181 VPWR VGND VPWR VGND sky130_ef_sc_hd__decap_12
XFILLER_0_17_107 VGND VGND VPWR VPWR sky130_fd_sc_hd__decap_4
XFILLER_0_31_30 VGND VGND VPWR VPWR sky130_fd_sc_hd__fill_1
XFILLER_0_40_176 VGND VGND VPWR VPWR sky130_fd_sc_hd__decap_8
XFILLER_0_31_63 VGND VGND VPWR VPWR sky130_fd_sc_hd__fill_1
X_0479_ net10 VGND VGND VPWR VPWR _0174_ sky130_fd_sc_hd__buf_2
X_0548_ _0214_ VGND VGND VPWR VPWR _0035_ sky130_fd_sc_hd__clkbuf_1
X_0617_ memory\[4\]\[5\] memory\[5\]\[5\] memory\[6\]\[5\] memory\[7\]\[5\] read_pointer\[0\]
+ read_pointer\[1\] VGND VGND VPWR VPWR _0273_ sky130_fd_sc_hd__mux4_1
XFILLER_0_48_221 VPWR VGND VPWR VGND sky130_ef_sc_hd__decap_12
XFILLER_0_48_265 VPWR VGND VPWR VGND sky130_ef_sc_hd__decap_12
XFILLER_0_31_165 VGND VGND VPWR VPWR sky130_fd_sc_hd__decap_3
XFILLER_0_26_85 VGND VGND VPWR VPWR sky130_fd_sc_hd__decap_4
XFILLER_0_45_279 VGND VGND VPWR VPWR sky130_fd_sc_hd__fill_1
XFILLER_0_42_40 VGND VGND VPWR VPWR sky130_fd_sc_hd__decap_3
XTAP_371 VGND VPWR sky130_fd_sc_hd__tapvpwrvgnd_1
XTAP_360 VGND VPWR sky130_fd_sc_hd__tapvpwrvgnd_1
XPHY_99 VGND VGND VPWR VPWR sky130_fd_sc_hd__decap_3
XPHY_88 VGND VGND VPWR VPWR sky130_fd_sc_hd__decap_3
XPHY_77 VGND VGND VPWR VPWR sky130_fd_sc_hd__decap_3
XPHY_66 VGND VGND VPWR VPWR sky130_fd_sc_hd__decap_3
XPHY_11 VGND VGND VPWR VPWR sky130_fd_sc_hd__decap_3
XPHY_22 VGND VGND VPWR VPWR sky130_fd_sc_hd__decap_3
XPHY_33 VGND VGND VPWR VPWR sky130_fd_sc_hd__decap_3
XPHY_44 VGND VGND VPWR VPWR sky130_fd_sc_hd__decap_3
XPHY_55 VGND VGND VPWR VPWR sky130_fd_sc_hd__decap_3
XFILLER_0_51_249 VGND VGND VPWR VPWR sky130_fd_sc_hd__decap_3
XFILLER_0_51_205 VGND VGND VPWR VPWR sky130_fd_sc_hd__fill_1
X_0951_ clknet_4_0_0_clk _0055_ VGND VGND VPWR VPWR memory\[12\]\[6\] sky130_fd_sc_hd__dfxtp_1
XFILLER_0_12_65 VGND VGND VPWR VPWR sky130_fd_sc_hd__decap_4
X_0882_ _0297_ _0220_ _0434_ VGND VGND VPWR VPWR _0435_ sky130_fd_sc_hd__a21oi_1
XFILLER_0_42_249 VGND VGND VPWR VPWR sky130_fd_sc_hd__decap_3
XFILLER_0_10_113 VGND VGND VPWR VPWR sky130_fd_sc_hd__fill_2
XFILLER_0_37_51 VGND VGND VPWR VPWR sky130_fd_sc_hd__decap_4
XFILLER_0_5_151 VGND VGND VPWR VPWR sky130_fd_sc_hd__fill_1
XFILLER_0_41_293 VPWR VGND VPWR VGND sky130_ef_sc_hd__decap_12
XTAP_190 VGND VPWR sky130_fd_sc_hd__tapvpwrvgnd_1
XFILLER_0_32_293 VPWR VGND VPWR VGND sky130_ef_sc_hd__decap_12
X_0865_ net164 _0419_ VGND VGND VPWR VPWR _0421_ sky130_fd_sc_hd__nand2_1
X_0934_ clknet_4_4_0_clk _0038_ VGND VGND VPWR VPWR memory\[1\]\[5\] sky130_fd_sc_hd__dfxtp_1
XFILLER_0_48_94 VGND VGND VPWR VPWR sky130_fd_sc_hd__decap_3
XFILLER_0_48_61 VGND VGND VPWR VPWR sky130_fd_sc_hd__fill_1
X_0796_ _0168_ net69 _0376_ VGND VGND VPWR VPWR _0381_ sky130_fd_sc_hd__mux2_1
XFILLER_0_3_52 VGND VGND VPWR VPWR sky130_fd_sc_hd__decap_4
XFILLER_0_14_282 VPWR VGND VPWR VGND sky130_ef_sc_hd__decap_12
XFILLER_0_21_208 VGND VGND VPWR VPWR sky130_fd_sc_hd__decap_4
X_0650_ _0302_ VGND VGND VPWR VPWR _0049_ sky130_fd_sc_hd__clkbuf_1
X_0581_ read_pointer\[3\] _0240_ VGND VGND VPWR VPWR _0241_ sky130_fd_sc_hd__and2b_1
Xclkbuf_4_1_0_clk clknet_0_clk VGND VGND VPWR VPWR clknet_4_1_0_clk sky130_fd_sc_hd__clkbuf_8
XFILLER_0_18_97 VGND VGND VPWR VPWR sky130_fd_sc_hd__decap_3
XFILLER_0_26_9 VGND VGND VPWR VPWR sky130_fd_sc_hd__decap_3
XFILLER_0_47_138 VGND VGND VPWR VPWR sky130_fd_sc_hd__decap_4
XFILLER_0_34_85 VPWR VGND VPWR VGND sky130_ef_sc_hd__decap_12
XFILLER_0_34_41 VGND VGND VPWR VPWR sky130_fd_sc_hd__decap_4
XFILLER_0_7_213 VGND VGND VPWR VPWR sky130_fd_sc_hd__decap_8
XFILLER_0_50_73 VGND VGND VPWR VPWR sky130_fd_sc_hd__fill_2
X_0779_ net32 net7 _0367_ VGND VGND VPWR VPWR _0372_ sky130_fd_sc_hd__mux2_1
XFILLER_0_7_268 VPWR VGND VPWR VGND sky130_ef_sc_hd__decap_12
X_0917_ clknet_4_9_0_clk _0021_ VGND VGND VPWR VPWR memory\[13\]\[4\] sky130_fd_sc_hd__dfxtp_1
X_0848_ _0409_ VGND VGND VPWR VPWR _0140_ sky130_fd_sc_hd__clkbuf_1
XFILLER_0_11_252 VPWR VGND VPWR VGND sky130_ef_sc_hd__decap_12
XFILLER_0_38_116 VPWR VGND VPWR VGND sky130_ef_sc_hd__decap_12
Xhold7 memory\[0\]\[4\] VGND VGND VPWR VPWR net32 sky130_fd_sc_hd__dlygate4sd3_1
XFILLER_0_37_160 VGND VGND VPWR VPWR sky130_fd_sc_hd__decap_8
X_0702_ net36 net3 _0330_ VGND VGND VPWR VPWR _0331_ sky130_fd_sc_hd__mux2_1
X_0633_ net162 _0221_ _0283_ _0287_ _0236_ VGND VGND VPWR VPWR _0047_ sky130_fd_sc_hd__o221a_1
XFILLER_0_20_76 VGND VGND VPWR VPWR sky130_fd_sc_hd__decap_4
X_0495_ _0168_ net83 _0179_ VGND VGND VPWR VPWR _0184_ sky130_fd_sc_hd__mux2_1
X_0564_ memory\[8\]\[0\] memory\[9\]\[0\] memory\[10\]\[0\] memory\[11\]\[0\] _0223_
+ _0224_ VGND VGND VPWR VPWR _0225_ sky130_fd_sc_hd__mux4_1
XFILLER_0_29_30 VGND VGND VPWR VPWR sky130_fd_sc_hd__decap_8
XFILLER_0_29_74 VPWR VGND VPWR VGND sky130_ef_sc_hd__decap_12
XFILLER_0_45_51 VGND VGND VPWR VPWR sky130_fd_sc_hd__decap_4
XFILLER_0_0_97 VGND VGND VPWR VPWR sky130_fd_sc_hd__decap_4
XFILLER_0_9_51 VGND VGND VPWR VPWR sky130_fd_sc_hd__decap_4
XFILLER_0_16_300 VGND VGND VPWR VPWR sky130_fd_sc_hd__decap_4
XFILLER_0_3_293 VPWR VGND VPWR VGND sky130_ef_sc_hd__decap_12
XFILLER_0_26_108 VGND VGND VPWR VPWR sky130_fd_sc_hd__decap_6
XFILLER_0_19_193 VPWR VGND VPWR VGND sky130_ef_sc_hd__decap_12
XFILLER_0_15_21 VGND VGND VPWR VPWR sky130_fd_sc_hd__fill_1
XFILLER_0_15_54 VGND VGND VPWR VPWR sky130_fd_sc_hd__fill_2
XFILLER_0_31_53 VGND VGND VPWR VPWR sky130_fd_sc_hd__decap_3
X_0616_ memory\[0\]\[5\] memory\[1\]\[5\] memory\[2\]\[5\] memory\[3\]\[5\] _0231_
+ _0237_ VGND VGND VPWR VPWR _0272_ sky130_fd_sc_hd__mux4_1
X_0547_ _0164_ net102 _0211_ VGND VGND VPWR VPWR _0214_ sky130_fd_sc_hd__mux2_1
X_0478_ _0173_ VGND VGND VPWR VPWR _0006_ sky130_fd_sc_hd__clkbuf_1
XFILLER_0_22_3 VPWR VGND VPWR VGND sky130_ef_sc_hd__decap_12
XFILLER_0_48_277 VPWR VGND VPWR VGND sky130_ef_sc_hd__decap_12
XFILLER_0_48_233 VPWR VGND VPWR VGND sky130_ef_sc_hd__decap_12
XFILLER_0_31_111 VGND VGND VPWR VPWR sky130_fd_sc_hd__fill_1
XFILLER_0_42_85 VGND VGND VPWR VPWR sky130_fd_sc_hd__fill_1
XFILLER_0_13_111 VGND VGND VPWR VPWR sky130_fd_sc_hd__fill_1
XTAP_350 VGND VPWR sky130_fd_sc_hd__tapvpwrvgnd_1
XFILLER_0_6_85 VPWR VGND VPWR VGND sky130_ef_sc_hd__decap_12
XTAP_372 VGND VPWR sky130_fd_sc_hd__tapvpwrvgnd_1
XTAP_361 VGND VPWR sky130_fd_sc_hd__tapvpwrvgnd_1
XPHY_12 VGND VGND VPWR VPWR sky130_fd_sc_hd__decap_3
XPHY_89 VGND VGND VPWR VPWR sky130_fd_sc_hd__decap_3
XPHY_78 VGND VGND VPWR VPWR sky130_fd_sc_hd__decap_3
XFILLER_0_36_236 VGND VGND VPWR VPWR sky130_fd_sc_hd__decap_4
XPHY_67 VGND VGND VPWR VPWR sky130_fd_sc_hd__decap_3
XPHY_23 VGND VGND VPWR VPWR sky130_fd_sc_hd__decap_3
XPHY_34 VGND VGND VPWR VPWR sky130_fd_sc_hd__decap_3
XPHY_45 VGND VGND VPWR VPWR sky130_fd_sc_hd__decap_3
XPHY_56 VGND VGND VPWR VPWR sky130_fd_sc_hd__decap_3
XFILLER_0_8_193 VGND VGND VPWR VPWR sky130_fd_sc_hd__decap_3
X_0950_ clknet_4_0_0_clk _0054_ VGND VGND VPWR VPWR memory\[12\]\[5\] sky130_fd_sc_hd__dfxtp_1
XFILLER_0_12_55 VGND VGND VPWR VPWR sky130_fd_sc_hd__fill_1
X_0881_ data_count\[3\] VGND VGND VPWR VPWR _0434_ sky130_fd_sc_hd__inv_2
XFILLER_0_27_225 VGND VGND VPWR VPWR sky130_fd_sc_hd__fill_1
XFILLER_0_27_236 VGND VGND VPWR VPWR sky130_fd_sc_hd__fill_1
XFILLER_0_10_158 VGND VGND VPWR VPWR sky130_fd_sc_hd__fill_2
XFILLER_0_37_41 VGND VGND VPWR VPWR sky130_fd_sc_hd__fill_1
XTAP_180 VGND VPWR sky130_fd_sc_hd__tapvpwrvgnd_1
XTAP_191 VGND VPWR sky130_fd_sc_hd__tapvpwrvgnd_1
XFILLER_0_24_217 VGND VGND VPWR VPWR sky130_fd_sc_hd__fill_1
XFILLER_0_23_65 VGND VGND VPWR VPWR sky130_fd_sc_hd__fill_2
X_0933_ clknet_4_15_0_clk _0037_ VGND VGND VPWR VPWR memory\[1\]\[4\] sky130_fd_sc_hd__dfxtp_1
X_0795_ _0380_ VGND VGND VPWR VPWR _0116_ sky130_fd_sc_hd__clkbuf_1
X_0864_ data_count\[0\] _0419_ VGND VGND VPWR VPWR _0420_ sky130_fd_sc_hd__or2_1
XFILLER_0_14_294 VPWR VGND VPWR VGND sky130_ef_sc_hd__decap_12
X_0580_ _0238_ _0239_ read_pointer\[2\] VGND VGND VPWR VPWR _0240_ sky130_fd_sc_hd__mux2_1
XFILLER_0_20_253 VGND VGND VPWR VPWR sky130_fd_sc_hd__decap_8
XFILLER_0_18_76 VGND VGND VPWR VPWR sky130_fd_sc_hd__decap_8
XFILLER_0_50_41 VPWR VGND VPWR VGND sky130_ef_sc_hd__decap_12
XFILLER_0_34_97 VPWR VGND VPWR VGND sky130_ef_sc_hd__decap_12
XFILLER_0_7_225 VGND VGND VPWR VPWR sky130_fd_sc_hd__decap_3
X_0916_ clknet_4_1_0_clk _0020_ VGND VGND VPWR VPWR memory\[13\]\[3\] sky130_fd_sc_hd__dfxtp_1
X_0778_ _0371_ VGND VGND VPWR VPWR _0108_ sky130_fd_sc_hd__clkbuf_1
X_0847_ _0155_ _0407_ _0408_ VGND VGND VPWR VPWR _0409_ sky130_fd_sc_hd__and3_1
XFILLER_0_11_264 VPWR VGND VPWR VGND sky130_ef_sc_hd__decap_12
XFILLER_0_38_128 VPWR VGND VPWR VGND sky130_ef_sc_hd__decap_12
Xhold8 memory\[8\]\[2\] VGND VGND VPWR VPWR net33 sky130_fd_sc_hd__dlygate4sd3_1
X_0632_ _0222_ _0286_ _0229_ VGND VGND VPWR VPWR _0287_ sky130_fd_sc_hd__a21o_1
X_0701_ _0329_ VGND VGND VPWR VPWR _0330_ sky130_fd_sc_hd__buf_4
X_0563_ read_pointer\[1\] VGND VGND VPWR VPWR _0224_ sky130_fd_sc_hd__buf_4
X_0494_ _0183_ VGND VGND VPWR VPWR _0012_ sky130_fd_sc_hd__clkbuf_1
XFILLER_0_29_86 VGND VGND VPWR VPWR sky130_fd_sc_hd__decap_8
XFILLER_0_0_21 VGND VGND VPWR VPWR sky130_fd_sc_hd__decap_6
X_1046_ clknet_4_11_0_clk _0150_ VGND VGND VPWR VPWR data_count\[4\] sky130_fd_sc_hd__dfxtp_4
XFILLER_0_3_261 VPWR VGND VPWR VGND sky130_ef_sc_hd__decap_12
Xclkbuf_4_0_0_clk clknet_0_clk VGND VGND VPWR VPWR clknet_4_0_0_clk sky130_fd_sc_hd__clkbuf_8
XFILLER_0_31_43 VGND VGND VPWR VPWR sky130_fd_sc_hd__fill_1
X_0546_ _0213_ VGND VGND VPWR VPWR _0034_ sky130_fd_sc_hd__clkbuf_1
XFILLER_0_0_253 VPWR VGND VPWR VGND sky130_ef_sc_hd__decap_12
XFILLER_0_0_275 VGND VGND VPWR VPWR sky130_fd_sc_hd__decap_4
X_0615_ net143 _0221_ _0267_ _0271_ _0236_ VGND VGND VPWR VPWR _0045_ sky130_fd_sc_hd__o221a_1
X_0477_ net139 _0172_ _0160_ VGND VGND VPWR VPWR _0173_ sky130_fd_sc_hd__mux2_1
XFILLER_0_15_3 VPWR VGND VPWR VGND sky130_ef_sc_hd__decap_12
XFILLER_0_48_289 VPWR VGND VPWR VGND sky130_ef_sc_hd__decap_12
XFILLER_0_48_245 VGND VGND VPWR VPWR sky130_fd_sc_hd__decap_6
X_1029_ clknet_4_13_0_clk _0133_ VGND VGND VPWR VPWR memory\[6\]\[4\] sky130_fd_sc_hd__dfxtp_1
XFILLER_0_22_178 VGND VGND VPWR VPWR sky130_fd_sc_hd__decap_3
XFILLER_0_13_167 VGND VGND VPWR VPWR sky130_fd_sc_hd__fill_1
XTAP_373 VGND VPWR sky130_fd_sc_hd__tapvpwrvgnd_1
XTAP_362 VGND VPWR sky130_fd_sc_hd__tapvpwrvgnd_1
XTAP_351 VGND VPWR sky130_fd_sc_hd__tapvpwrvgnd_1
XTAP_340 VGND VPWR sky130_fd_sc_hd__tapvpwrvgnd_1
X_0529_ net30 _0164_ _0201_ VGND VGND VPWR VPWR _0204_ sky130_fd_sc_hd__mux2_1
XFILLER_0_6_97 VPWR VGND VPWR VGND sky130_ef_sc_hd__decap_12
XPHY_13 VGND VGND VPWR VPWR sky130_fd_sc_hd__decap_3
XPHY_24 VGND VGND VPWR VPWR sky130_fd_sc_hd__decap_3
XPHY_35 VGND VGND VPWR VPWR sky130_fd_sc_hd__decap_3
XPHY_46 VGND VGND VPWR VPWR sky130_fd_sc_hd__decap_3
XPHY_79 VGND VGND VPWR VPWR sky130_fd_sc_hd__decap_3
XPHY_68 VGND VGND VPWR VPWR sky130_fd_sc_hd__decap_3
XPHY_57 VGND VGND VPWR VPWR sky130_fd_sc_hd__decap_3
XFILLER_0_4_3 VPWR VGND VPWR VGND sky130_ef_sc_hd__decap_12
XFILLER_0_27_204 VPWR VGND VPWR VGND sky130_ef_sc_hd__decap_12
XFILLER_0_50_240 VPWR VGND VPWR VGND sky130_ef_sc_hd__decap_12
XFILLER_0_42_229 VGND VGND VPWR VPWR sky130_fd_sc_hd__fill_1
XFILLER_0_35_281 VPWR VGND VPWR VGND sky130_ef_sc_hd__decap_12
XFILLER_0_6_109 VPWR VGND VPWR VGND sky130_ef_sc_hd__decap_12
XFILLER_0_12_78 VGND VGND VPWR VPWR sky130_fd_sc_hd__decap_6
X_0880_ data_count\[2\] _0427_ _0419_ VGND VGND VPWR VPWR _0433_ sky130_fd_sc_hd__o21a_1
XFILLER_0_26_292 VGND VGND VPWR VPWR sky130_fd_sc_hd__decap_8
XTAP_170 VGND VPWR sky130_fd_sc_hd__tapvpwrvgnd_1
XTAP_181 VGND VPWR sky130_fd_sc_hd__tapvpwrvgnd_1
XTAP_192 VGND VPWR sky130_fd_sc_hd__tapvpwrvgnd_1
XFILLER_0_32_251 VGND VGND VPWR VPWR sky130_fd_sc_hd__fill_1
XFILLER_0_17_281 VPWR VGND VPWR VGND sky130_ef_sc_hd__decap_12
X_0932_ clknet_4_7_0_clk _0036_ VGND VGND VPWR VPWR memory\[1\]\[3\] sky130_fd_sc_hd__dfxtp_1
X_0794_ _0166_ net151 _0376_ VGND VGND VPWR VPWR _0380_ sky130_fd_sc_hd__mux2_1
XFILLER_0_2_123 VGND VGND VPWR VPWR sky130_fd_sc_hd__fill_1
X_0863_ _0297_ _0220_ VGND VGND VPWR VPWR _0419_ sky130_fd_sc_hd__xnor2_2
XFILLER_0_23_295 VPWR VGND VPWR VGND sky130_ef_sc_hd__decap_12
XFILLER_0_48_41 VPWR VGND VPWR VGND sky130_ef_sc_hd__decap_12
XFILLER_0_14_251 VGND VGND VPWR VPWR sky130_fd_sc_hd__fill_1
XFILLER_0_20_221 VPWR VGND VPWR VGND sky130_ef_sc_hd__decap_12
XFILLER_0_18_22 VGND VGND VPWR VPWR sky130_fd_sc_hd__decap_6
XFILLER_0_20_265 VGND VGND VPWR VPWR sky130_fd_sc_hd__decap_6
XFILLER_0_50_53 VPWR VGND VPWR VGND sky130_ef_sc_hd__decap_12
X_0915_ clknet_4_8_0_clk _0019_ VGND VGND VPWR VPWR memory\[13\]\[2\] sky130_fd_sc_hd__dfxtp_1
X_0777_ net121 net6 _0367_ VGND VGND VPWR VPWR _0371_ sky130_fd_sc_hd__mux2_1
XFILLER_0_11_276 VGND VGND VPWR VPWR sky130_fd_sc_hd__decap_4
X_0846_ write_pointer\[2\] _0157_ VGND VGND VPWR VPWR _0408_ sky130_fd_sc_hd__or2_1
XFILLER_0_45_3 VPWR VGND VPWR VGND sky130_ef_sc_hd__decap_12
XFILLER_0_46_195 VGND VGND VPWR VPWR sky130_fd_sc_hd__fill_1
Xhold9 memory\[4\]\[4\] VGND VGND VPWR VPWR net34 sky130_fd_sc_hd__dlygate4sd3_1
XFILLER_0_4_218 VPWR VGND VPWR VGND sky130_ef_sc_hd__decap_12
XFILLER_0_4_207 VGND VGND VPWR VPWR sky130_fd_sc_hd__decap_3
X_0700_ net2 _0157_ _0328_ VGND VGND VPWR VPWR _0329_ sky130_fd_sc_hd__and3_1
X_0631_ _0284_ _0285_ _0227_ VGND VGND VPWR VPWR _0286_ sky130_fd_sc_hd__mux2_1
XFILLER_0_20_56 VGND VGND VPWR VPWR sky130_fd_sc_hd__decap_4
X_0562_ read_pointer\[0\] VGND VGND VPWR VPWR _0223_ sky130_fd_sc_hd__buf_4
X_0493_ _0166_ net124 _0179_ VGND VGND VPWR VPWR _0183_ sky130_fd_sc_hd__mux2_1
XFILLER_0_29_54 VGND VGND VPWR VPWR sky130_fd_sc_hd__fill_2
XFILLER_0_0_55 VGND VGND VPWR VPWR sky130_fd_sc_hd__fill_1
X_1045_ clknet_4_11_0_clk _0149_ VGND VGND VPWR VPWR data_count\[3\] sky130_fd_sc_hd__dfxtp_1
X_0829_ _0166_ net130 _0395_ VGND VGND VPWR VPWR _0399_ sky130_fd_sc_hd__mux2_1
XFILLER_0_31_305 VGND VGND VPWR VPWR sky130_fd_sc_hd__fill_2
XFILLER_0_3_273 VGND VGND VPWR VPWR sky130_fd_sc_hd__decap_6
XFILLER_0_22_305 VGND VGND VPWR VPWR sky130_fd_sc_hd__fill_2
XFILLER_0_15_34 VPWR VGND VPWR VGND sky130_ef_sc_hd__decap_12
XFILLER_0_13_305 VGND VGND VPWR VPWR sky130_fd_sc_hd__fill_2
X_0545_ _0162_ net111 _0211_ VGND VGND VPWR VPWR _0213_ sky130_fd_sc_hd__mux2_1
XFILLER_0_0_265 VGND VGND VPWR VPWR sky130_fd_sc_hd__decap_4
X_0476_ net9 VGND VGND VPWR VPWR _0172_ sky130_fd_sc_hd__buf_2
X_0614_ _0222_ _0270_ _0229_ VGND VGND VPWR VPWR _0271_ sky130_fd_sc_hd__a21o_1
X_1028_ clknet_4_7_0_clk _0132_ VGND VGND VPWR VPWR memory\[6\]\[3\] sky130_fd_sc_hd__dfxtp_1
XFILLER_0_31_113 VPWR VGND VPWR VGND sky130_ef_sc_hd__decap_12
XFILLER_0_31_157 VGND VGND VPWR VPWR sky130_fd_sc_hd__decap_8
XFILLER_0_45_249 VPWR VGND VPWR VGND sky130_ef_sc_hd__decap_12
XFILLER_0_13_113 VPWR VGND VPWR VGND sky130_ef_sc_hd__decap_12
XTAP_363 VGND VPWR sky130_fd_sc_hd__tapvpwrvgnd_1
XTAP_352 VGND VPWR sky130_fd_sc_hd__tapvpwrvgnd_1
X_0528_ _0203_ VGND VGND VPWR VPWR _0026_ sky130_fd_sc_hd__clkbuf_1
XTAP_341 VGND VPWR sky130_fd_sc_hd__tapvpwrvgnd_1
XTAP_330 VGND VPWR sky130_fd_sc_hd__tapvpwrvgnd_1
X_0459_ net55 _0154_ _0160_ VGND VGND VPWR VPWR _0161_ sky130_fd_sc_hd__mux2_1
XFILLER_0_21_190 VPWR VGND VPWR VGND sky130_ef_sc_hd__decap_12
XPHY_69 VGND VGND VPWR VPWR sky130_fd_sc_hd__decap_3
XPHY_14 VGND VGND VPWR VPWR sky130_fd_sc_hd__decap_3
XPHY_25 VGND VGND VPWR VPWR sky130_fd_sc_hd__decap_3
XPHY_36 VGND VGND VPWR VPWR sky130_fd_sc_hd__decap_3
XPHY_47 VGND VGND VPWR VPWR sky130_fd_sc_hd__decap_3
XPHY_58 VGND VGND VPWR VPWR sky130_fd_sc_hd__decap_3
XFILLER_0_8_162 VGND VGND VPWR VPWR sky130_fd_sc_hd__decap_3
XFILLER_0_8_173 VPWR VGND VPWR VGND sky130_ef_sc_hd__decap_12
XFILLER_0_27_216 VGND VGND VPWR VPWR sky130_fd_sc_hd__fill_1
XFILLER_0_35_293 VGND VGND VPWR VPWR sky130_fd_sc_hd__decap_8
XFILLER_0_5_121 VPWR VGND VPWR VGND sky130_ef_sc_hd__decap_12
XTAP_160 VGND VPWR sky130_fd_sc_hd__tapvpwrvgnd_1
XTAP_171 VGND VPWR sky130_fd_sc_hd__tapvpwrvgnd_1
XTAP_182 VGND VPWR sky130_fd_sc_hd__tapvpwrvgnd_1
XTAP_193 VGND VPWR sky130_fd_sc_hd__tapvpwrvgnd_1
XFILLER_0_17_293 VPWR VGND VPWR VGND sky130_ef_sc_hd__decap_12
X_0931_ clknet_4_15_0_clk _0035_ VGND VGND VPWR VPWR memory\[1\]\[2\] sky130_fd_sc_hd__dfxtp_1
X_0862_ _0222_ _0415_ _0418_ VGND VGND VPWR VPWR _0145_ sky130_fd_sc_hd__a21oi_1
XFILLER_0_23_34 VGND VGND VPWR VPWR sky130_fd_sc_hd__decap_6
X_0793_ _0379_ VGND VGND VPWR VPWR _0115_ sky130_fd_sc_hd__clkbuf_1
XFILLER_0_23_241 VGND VGND VPWR VPWR sky130_fd_sc_hd__decap_8
XFILLER_0_48_53 VGND VGND VPWR VPWR sky130_fd_sc_hd__decap_8
XFILLER_0_20_233 VPWR VGND VPWR VGND sky130_ef_sc_hd__decap_12
XFILLER_0_50_65 VGND VGND VPWR VPWR sky130_fd_sc_hd__decap_8
X_0845_ write_pointer\[2\] _0157_ VGND VGND VPWR VPWR _0407_ sky130_fd_sc_hd__nand2_1
X_0914_ clknet_4_8_0_clk _0018_ VGND VGND VPWR VPWR memory\[13\]\[1\] sky130_fd_sc_hd__dfxtp_1
X_0776_ _0370_ VGND VGND VPWR VPWR _0107_ sky130_fd_sc_hd__clkbuf_1
XFILLER_0_11_233 VGND VGND VPWR VPWR sky130_fd_sc_hd__fill_2
XFILLER_0_38_3 VPWR VGND VPWR VGND sky130_ef_sc_hd__decap_12
XFILLER_0_46_141 VGND VGND VPWR VPWR sky130_fd_sc_hd__decap_3
XFILLER_0_37_130 VGND VGND VPWR VPWR sky130_fd_sc_hd__fill_1
X_0492_ _0182_ VGND VGND VPWR VPWR _0011_ sky130_fd_sc_hd__clkbuf_1
X_0630_ memory\[12\]\[6\] memory\[13\]\[6\] memory\[14\]\[6\] memory\[15\]\[6\] _0223_
+ _0224_ VGND VGND VPWR VPWR _0285_ sky130_fd_sc_hd__mux4_1
X_0561_ read_pointer\[3\] VGND VGND VPWR VPWR _0222_ sky130_fd_sc_hd__clkbuf_4
XFILLER_0_45_87 VPWR VGND VPWR VGND sky130_ef_sc_hd__decap_12
X_1044_ clknet_4_11_0_clk _0148_ VGND VGND VPWR VPWR data_count\[2\] sky130_fd_sc_hd__dfxtp_2
XFILLER_0_43_100 VGND VGND VPWR VPWR sky130_fd_sc_hd__fill_1
XFILLER_0_28_130 VGND VGND VPWR VPWR sky130_fd_sc_hd__decap_6
XFILLER_0_43_166 VGND VGND VPWR VPWR sky130_fd_sc_hd__fill_2
X_0759_ _0361_ VGND VGND VPWR VPWR _0099_ sky130_fd_sc_hd__clkbuf_1
X_0828_ _0398_ VGND VGND VPWR VPWR _0131_ sky130_fd_sc_hd__clkbuf_1
XFILLER_0_15_46 VGND VGND VPWR VPWR sky130_fd_sc_hd__decap_8
XFILLER_0_15_57 VGND VGND VPWR VPWR sky130_fd_sc_hd__fill_2
XFILLER_0_40_147 VGND VGND VPWR VPWR sky130_fd_sc_hd__decap_4
X_0613_ _0268_ _0269_ _0227_ VGND VGND VPWR VPWR _0270_ sky130_fd_sc_hd__mux2_1
XFILLER_0_25_133 VPWR VGND VPWR VGND sky130_ef_sc_hd__decap_12
X_0544_ _0212_ VGND VGND VPWR VPWR _0033_ sky130_fd_sc_hd__clkbuf_1
X_0475_ _0171_ VGND VGND VPWR VPWR _0005_ sky130_fd_sc_hd__clkbuf_1
X_1027_ clknet_4_12_0_clk _0131_ VGND VGND VPWR VPWR memory\[6\]\[2\] sky130_fd_sc_hd__dfxtp_1
XFILLER_0_31_125 VGND VGND VPWR VPWR sky130_fd_sc_hd__decap_4
XFILLER_0_31_147 VGND VGND VPWR VPWR sky130_fd_sc_hd__fill_1
XFILLER_0_31_169 VPWR VGND VPWR VGND sky130_ef_sc_hd__decap_12
XFILLER_0_39_236 VPWR VGND VPWR VGND sky130_ef_sc_hd__decap_12
XFILLER_0_22_125 VPWR VGND VPWR VGND sky130_ef_sc_hd__decap_12
XFILLER_0_42_11 VGND VGND VPWR VPWR sky130_fd_sc_hd__fill_1
Xhold90 memory\[12\]\[7\] VGND VGND VPWR VPWR net115 sky130_fd_sc_hd__dlygate4sd3_1
XFILLER_0_45_206 VPWR VGND VPWR VGND sky130_ef_sc_hd__decap_12
XFILLER_0_6_66 VPWR VGND VPWR VGND sky130_ef_sc_hd__decap_12
XFILLER_0_13_125 VPWR VGND VPWR VGND sky130_ef_sc_hd__decap_12
XFILLER_0_13_169 VGND VGND VPWR VPWR sky130_fd_sc_hd__fill_2
XTAP_364 VGND VPWR sky130_fd_sc_hd__tapvpwrvgnd_1
XTAP_353 VGND VPWR sky130_fd_sc_hd__tapvpwrvgnd_1
XTAP_342 VGND VPWR sky130_fd_sc_hd__tapvpwrvgnd_1
X_0527_ net70 _0162_ _0201_ VGND VGND VPWR VPWR _0203_ sky130_fd_sc_hd__mux2_1
XTAP_331 VGND VPWR sky130_fd_sc_hd__tapvpwrvgnd_1
XTAP_320 VGND VPWR sky130_fd_sc_hd__tapvpwrvgnd_1
XFILLER_0_20_3 VGND VGND VPWR VPWR sky130_fd_sc_hd__decap_6
X_0458_ _0159_ VGND VGND VPWR VPWR _0160_ sky130_fd_sc_hd__clkbuf_4
XPHY_15 VGND VGND VPWR VPWR sky130_fd_sc_hd__decap_3
XPHY_26 VGND VGND VPWR VPWR sky130_fd_sc_hd__decap_3
XPHY_37 VGND VGND VPWR VPWR sky130_fd_sc_hd__decap_3
XPHY_48 VGND VGND VPWR VPWR sky130_fd_sc_hd__decap_3
XPHY_59 VGND VGND VPWR VPWR sky130_fd_sc_hd__decap_3
XFILLER_0_8_141 VGND VGND VPWR VPWR sky130_fd_sc_hd__decap_4
XFILLER_0_8_185 VGND VGND VPWR VPWR sky130_fd_sc_hd__decap_8
XFILLER_0_29_291 VPWR VGND VPWR VGND sky130_ef_sc_hd__decap_12
XFILLER_0_35_250 VPWR VGND VPWR VGND sky130_ef_sc_hd__decap_12
XFILLER_0_50_253 VPWR VGND VPWR VGND sky130_ef_sc_hd__decap_12
XFILLER_0_37_55 VGND VGND VPWR VPWR sky130_fd_sc_hd__fill_1
XFILLER_0_37_11 VGND VGND VPWR VPWR sky130_fd_sc_hd__fill_2
XFILLER_0_5_133 VPWR VGND VPWR VGND sky130_ef_sc_hd__decap_12
XFILLER_0_5_111 VGND VGND VPWR VPWR sky130_fd_sc_hd__fill_1
XTAP_150 VGND VPWR sky130_fd_sc_hd__tapvpwrvgnd_1
XTAP_161 VGND VPWR sky130_fd_sc_hd__tapvpwrvgnd_1
XTAP_172 VGND VPWR sky130_fd_sc_hd__tapvpwrvgnd_1
XTAP_183 VGND VPWR sky130_fd_sc_hd__tapvpwrvgnd_1
XTAP_194 VGND VPWR sky130_fd_sc_hd__tapvpwrvgnd_1
XFILLER_0_24_209 VGND VGND VPWR VPWR sky130_fd_sc_hd__decap_8
X_0930_ clknet_4_13_0_clk _0034_ VGND VGND VPWR VPWR memory\[1\]\[1\] sky130_fd_sc_hd__dfxtp_1
X_0792_ _0164_ net50 _0376_ VGND VGND VPWR VPWR _0379_ sky130_fd_sc_hd__mux2_1
X_0861_ _0222_ _0415_ _0236_ VGND VGND VPWR VPWR _0418_ sky130_fd_sc_hd__o21ai_1
XFILLER_0_46_301 VGND VGND VPWR VPWR sky130_fd_sc_hd__fill_2
XFILLER_0_14_253 VPWR VGND VPWR VGND sky130_ef_sc_hd__decap_12
XFILLER_0_20_245 VGND VGND VPWR VPWR sky130_fd_sc_hd__decap_6
XFILLER_0_34_45 VGND VGND VPWR VPWR sky130_fd_sc_hd__fill_1
X_0775_ net37 net5 _0367_ VGND VGND VPWR VPWR _0370_ sky130_fd_sc_hd__mux2_1
X_0913_ clknet_4_2_0_clk _0017_ VGND VGND VPWR VPWR memory\[13\]\[0\] sky130_fd_sc_hd__dfxtp_1
XFILLER_0_11_212 VPWR VGND VPWR VGND sky130_ef_sc_hd__decap_12
X_0844_ net27 _0188_ _0406_ VGND VGND VPWR VPWR _0139_ sky130_fd_sc_hd__o21a_1
XFILLER_0_20_47 VGND VGND VPWR VPWR sky130_fd_sc_hd__decap_6
XFILLER_0_25_304 VGND VGND VPWR VPWR sky130_fd_sc_hd__decap_3
X_0491_ _0164_ net80 _0179_ VGND VGND VPWR VPWR _0182_ sky130_fd_sc_hd__mux2_1
X_0560_ _0220_ VGND VGND VPWR VPWR _0221_ sky130_fd_sc_hd__clkbuf_4
XFILLER_0_45_99 VPWR VGND VPWR VGND sky130_ef_sc_hd__decap_12
XFILLER_0_45_55 VGND VGND VPWR VPWR sky130_fd_sc_hd__fill_1
X_1043_ clknet_4_14_0_clk _0147_ VGND VGND VPWR VPWR data_count\[1\] sky130_fd_sc_hd__dfxtp_1
XFILLER_0_0_57 VPWR VGND VPWR VGND sky130_ef_sc_hd__decap_12
XFILLER_0_28_197 VGND VGND VPWR VPWR sky130_fd_sc_hd__decap_3
XFILLER_0_43_156 VGND VGND VPWR VPWR sky130_fd_sc_hd__fill_1
X_0758_ net62 net5 _0358_ VGND VGND VPWR VPWR _0361_ sky130_fd_sc_hd__mux2_1
X_0827_ _0164_ net105 _0395_ VGND VGND VPWR VPWR _0398_ sky130_fd_sc_hd__mux2_1
XFILLER_0_9_55 VGND VGND VPWR VPWR sky130_fd_sc_hd__fill_1
XFILLER_0_50_3 VPWR VGND VPWR VGND sky130_ef_sc_hd__decap_12
X_0689_ _0166_ net120 _0319_ VGND VGND VPWR VPWR _0323_ sky130_fd_sc_hd__mux2_1
XFILLER_0_31_57 VGND VGND VPWR VPWR sky130_fd_sc_hd__decap_6
XFILLER_0_0_223 VGND VGND VPWR VPWR sky130_fd_sc_hd__fill_1
X_0612_ memory\[12\]\[4\] memory\[13\]\[4\] memory\[14\]\[4\] memory\[15\]\[4\] _0223_
+ _0224_ VGND VGND VPWR VPWR _0269_ sky130_fd_sc_hd__mux4_1
XFILLER_0_25_145 VGND VGND VPWR VPWR sky130_fd_sc_hd__decap_4
XFILLER_0_25_156 VGND VGND VPWR VPWR sky130_fd_sc_hd__decap_8
X_0543_ _0154_ net98 _0211_ VGND VGND VPWR VPWR _0212_ sky130_fd_sc_hd__mux2_1
X_0474_ net108 _0170_ _0160_ VGND VGND VPWR VPWR _0171_ sky130_fd_sc_hd__mux2_1
X_1026_ clknet_4_7_0_clk _0130_ VGND VGND VPWR VPWR memory\[6\]\[1\] sky130_fd_sc_hd__dfxtp_1
XFILLER_0_8_301 VGND VGND VPWR VPWR sky130_fd_sc_hd__decap_6
XFILLER_0_16_134 VGND VGND VPWR VPWR sky130_fd_sc_hd__decap_3
XFILLER_0_6_9 VGND VGND VPWR VPWR sky130_fd_sc_hd__decap_3
XFILLER_0_47_281 VPWR VGND VPWR VGND sky130_ef_sc_hd__decap_12
XFILLER_0_39_248 VPWR VGND VPWR VGND sky130_ef_sc_hd__decap_12
XFILLER_0_39_204 VPWR VGND VPWR VGND sky130_ef_sc_hd__decap_12
XFILLER_0_22_115 VGND VGND VPWR VPWR sky130_fd_sc_hd__fill_1
XFILLER_0_22_137 VGND VGND VPWR VPWR sky130_fd_sc_hd__decap_3
XFILLER_0_30_170 VGND VGND VPWR VPWR sky130_fd_sc_hd__decap_4
Xhold91 memory\[1\]\[4\] VGND VGND VPWR VPWR net116 sky130_fd_sc_hd__dlygate4sd3_1
Xhold80 memory\[6\]\[2\] VGND VGND VPWR VPWR net105 sky130_fd_sc_hd__dlygate4sd3_1
XFILLER_0_26_79 VGND VGND VPWR VPWR sky130_fd_sc_hd__decap_4
XFILLER_0_45_218 VGND VGND VPWR VPWR sky130_fd_sc_hd__decap_3
XTAP_332 VGND VPWR sky130_fd_sc_hd__tapvpwrvgnd_1
XTAP_321 VGND VPWR sky130_fd_sc_hd__tapvpwrvgnd_1
XTAP_310 VGND VPWR sky130_fd_sc_hd__tapvpwrvgnd_1
XFILLER_0_6_78 VGND VGND VPWR VPWR sky130_fd_sc_hd__decap_6
XFILLER_0_13_137 VPWR VGND VPWR VGND sky130_ef_sc_hd__decap_12
XFILLER_0_21_181 VGND VGND VPWR VPWR sky130_fd_sc_hd__fill_1
X_0526_ _0202_ VGND VGND VPWR VPWR _0025_ sky130_fd_sc_hd__clkbuf_1
XTAP_365 VGND VPWR sky130_fd_sc_hd__tapvpwrvgnd_1
XTAP_354 VGND VPWR sky130_fd_sc_hd__tapvpwrvgnd_1
XTAP_343 VGND VPWR sky130_fd_sc_hd__tapvpwrvgnd_1
XFILLER_0_13_3 VGND VGND VPWR VPWR sky130_fd_sc_hd__decap_8
X_0457_ _0155_ _0157_ _0158_ VGND VGND VPWR VPWR _0159_ sky130_fd_sc_hd__and3_1
XPHY_16 VGND VGND VPWR VPWR sky130_fd_sc_hd__decap_3
XPHY_27 VGND VGND VPWR VPWR sky130_fd_sc_hd__decap_3
XPHY_38 VGND VGND VPWR VPWR sky130_fd_sc_hd__decap_3
XPHY_49 VGND VGND VPWR VPWR sky130_fd_sc_hd__decap_3
X_1009_ clknet_4_6_0_clk _0113_ VGND VGND VPWR VPWR memory\[5\]\[0\] sky130_fd_sc_hd__dfxtp_1
XFILLER_0_44_251 VGND VGND VPWR VPWR sky130_fd_sc_hd__fill_1
XFILLER_0_8_197 VGND VGND VPWR VPWR sky130_fd_sc_hd__decap_3
XFILLER_0_35_262 VPWR VGND VPWR VGND sky130_ef_sc_hd__decap_12
XFILLER_0_12_26 VGND VGND VPWR VPWR sky130_fd_sc_hd__fill_2
XFILLER_0_50_265 VPWR VGND VPWR VGND sky130_ef_sc_hd__decap_12
XFILLER_0_5_178 VGND VGND VPWR VPWR sky130_fd_sc_hd__fill_1
XFILLER_0_5_145 VGND VGND VPWR VPWR sky130_fd_sc_hd__decap_6
XFILLER_0_26_251 VGND VGND VPWR VPWR sky130_fd_sc_hd__fill_1
XTAP_140 VGND VPWR sky130_fd_sc_hd__tapvpwrvgnd_1
X_0509_ _0192_ VGND VGND VPWR VPWR _0018_ sky130_fd_sc_hd__clkbuf_1
XTAP_151 VGND VPWR sky130_fd_sc_hd__tapvpwrvgnd_1
XTAP_162 VGND VPWR sky130_fd_sc_hd__tapvpwrvgnd_1
XTAP_173 VGND VPWR sky130_fd_sc_hd__tapvpwrvgnd_1
XTAP_184 VGND VPWR sky130_fd_sc_hd__tapvpwrvgnd_1
XTAP_195 VGND VPWR sky130_fd_sc_hd__tapvpwrvgnd_1
XFILLER_0_2_3 VPWR VGND VPWR VGND sky130_ef_sc_hd__decap_12
X_0791_ _0378_ VGND VGND VPWR VPWR _0114_ sky130_fd_sc_hd__clkbuf_1
X_0860_ _0417_ VGND VGND VPWR VPWR _0144_ sky130_fd_sc_hd__clkbuf_1
XFILLER_0_2_159 VGND VGND VPWR VPWR sky130_fd_sc_hd__fill_1
XFILLER_0_3_35 VGND VGND VPWR VPWR sky130_fd_sc_hd__fill_2
XFILLER_0_14_265 VPWR VGND VPWR VGND sky130_ef_sc_hd__decap_12
X_0989_ clknet_4_11_0_clk _0093_ VGND VGND VPWR VPWR memory\[10\]\[4\] sky130_fd_sc_hd__dfxtp_1
XFILLER_0_9_281 VPWR VGND VPWR VGND sky130_ef_sc_hd__decap_12
XFILLER_0_20_279 VGND VGND VPWR VPWR sky130_fd_sc_hd__decap_4
XFILLER_0_18_47 VGND VGND VPWR VPWR sky130_fd_sc_hd__decap_4
X_0912_ clknet_4_5_0_clk _0016_ VGND VGND VPWR VPWR memory\[2\]\[7\] sky130_fd_sc_hd__dfxtp_1
XFILLER_0_43_305 VGND VGND VPWR VPWR sky130_fd_sc_hd__fill_2
XFILLER_0_34_79 VGND VGND VPWR VPWR sky130_fd_sc_hd__decap_4
X_0774_ _0369_ VGND VGND VPWR VPWR _0106_ sky130_fd_sc_hd__clkbuf_1
X_0843_ _0296_ _0157_ VGND VGND VPWR VPWR _0406_ sky130_fd_sc_hd__nor2_1
XFILLER_0_34_305 VGND VGND VPWR VPWR sky130_fd_sc_hd__fill_2
XFILLER_0_6_251 VGND VGND VPWR VPWR sky130_fd_sc_hd__fill_1
XFILLER_0_20_26 VGND VGND VPWR VPWR sky130_fd_sc_hd__fill_2
X_0490_ _0181_ VGND VGND VPWR VPWR _0010_ sky130_fd_sc_hd__clkbuf_1
X_1042_ clknet_4_14_0_clk _0146_ VGND VGND VPWR VPWR data_count\[0\] sky130_fd_sc_hd__dfxtp_1
XFILLER_0_0_69 VPWR VGND VPWR VGND sky130_ef_sc_hd__decap_12
XFILLER_0_28_121 VGND VGND VPWR VPWR sky130_fd_sc_hd__decap_6
X_0826_ _0397_ VGND VGND VPWR VPWR _0130_ sky130_fd_sc_hd__clkbuf_1
X_0757_ _0360_ VGND VGND VPWR VPWR _0098_ sky130_fd_sc_hd__clkbuf_1
X_0688_ _0322_ VGND VGND VPWR VPWR _0067_ sky130_fd_sc_hd__clkbuf_1
XFILLER_0_9_89 VGND VGND VPWR VPWR sky130_fd_sc_hd__decap_3
XFILLER_0_43_3 VPWR VGND VPWR VGND sky130_ef_sc_hd__decap_12
Xclkbuf_4_15_0_clk clknet_0_clk VGND VGND VPWR VPWR clknet_4_15_0_clk sky130_fd_sc_hd__clkbuf_8
XFILLER_0_19_143 VPWR VGND VPWR VGND sky130_ef_sc_hd__decap_12
XFILLER_0_15_15 VGND VGND VPWR VPWR sky130_fd_sc_hd__decap_6
XFILLER_0_40_138 VGND VGND VPWR VPWR sky130_fd_sc_hd__fill_2
XFILLER_0_40_105 VPWR VGND VPWR VGND sky130_ef_sc_hd__decap_12
XFILLER_0_0_279 VGND VGND VPWR VPWR sky130_fd_sc_hd__fill_1
X_0611_ memory\[8\]\[4\] memory\[9\]\[4\] memory\[10\]\[4\] memory\[11\]\[4\] _0242_
+ _0243_ VGND VGND VPWR VPWR _0268_ sky130_fd_sc_hd__mux4_1
X_0542_ _0210_ _0189_ VGND VGND VPWR VPWR _0211_ sky130_fd_sc_hd__nand2b_4
X_0473_ net8 VGND VGND VPWR VPWR _0170_ sky130_fd_sc_hd__buf_2
X_1025_ clknet_4_6_0_clk _0129_ VGND VGND VPWR VPWR memory\[6\]\[0\] sky130_fd_sc_hd__dfxtp_1
X_0809_ _0388_ VGND VGND VPWR VPWR _0122_ sky130_fd_sc_hd__clkbuf_1
XFILLER_0_16_157 VGND VGND VPWR VPWR sky130_fd_sc_hd__fill_1
XFILLER_0_39_216 VGND VGND VPWR VPWR sky130_fd_sc_hd__decap_8
XFILLER_0_47_293 VPWR VGND VPWR VGND sky130_ef_sc_hd__decap_12
Xhold70 memory\[3\]\[6\] VGND VGND VPWR VPWR net95 sky130_fd_sc_hd__dlygate4sd3_1
Xhold81 memory\[13\]\[1\] VGND VGND VPWR VPWR net106 sky130_fd_sc_hd__dlygate4sd3_1
Xhold92 memory\[13\]\[3\] VGND VGND VPWR VPWR net117 sky130_fd_sc_hd__dlygate4sd3_1
XFILLER_0_5_305 VGND VGND VPWR VPWR sky130_fd_sc_hd__fill_2
XFILLER_0_13_149 VPWR VGND VPWR VGND sky130_ef_sc_hd__decap_12
XTAP_366 VGND VPWR sky130_fd_sc_hd__tapvpwrvgnd_1
XTAP_355 VGND VPWR sky130_fd_sc_hd__tapvpwrvgnd_1
XTAP_344 VGND VPWR sky130_fd_sc_hd__tapvpwrvgnd_1
XTAP_333 VGND VPWR sky130_fd_sc_hd__tapvpwrvgnd_1
XTAP_322 VGND VPWR sky130_fd_sc_hd__tapvpwrvgnd_1
XTAP_311 VGND VPWR sky130_fd_sc_hd__tapvpwrvgnd_1
XTAP_300 VGND VPWR sky130_fd_sc_hd__tapvpwrvgnd_1
X_0456_ write_pointer\[3\] write_pointer\[2\] VGND VGND VPWR VPWR _0158_ sky130_fd_sc_hd__and2_2
X_0525_ net90 _0154_ _0201_ VGND VGND VPWR VPWR _0202_ sky130_fd_sc_hd__mux2_1
XPHY_17 VGND VGND VPWR VPWR sky130_fd_sc_hd__decap_3
XPHY_28 VGND VGND VPWR VPWR sky130_fd_sc_hd__decap_3
X_1008_ clknet_4_5_0_clk _0112_ VGND VGND VPWR VPWR memory\[0\]\[7\] sky130_fd_sc_hd__dfxtp_1
XFILLER_0_8_154 VGND VGND VPWR VPWR sky130_fd_sc_hd__decap_8
XPHY_39 VGND VGND VPWR VPWR sky130_fd_sc_hd__decap_3
XFILLER_0_35_274 VGND VGND VPWR VPWR sky130_fd_sc_hd__decap_6
XFILLER_0_50_277 VPWR VGND VPWR VGND sky130_ef_sc_hd__decap_12
XFILLER_0_26_241 VGND VGND VPWR VPWR sky130_fd_sc_hd__fill_2
X_0508_ _0162_ net106 _0190_ VGND VGND VPWR VPWR _0192_ sky130_fd_sc_hd__mux2_1
XTAP_141 VGND VPWR sky130_fd_sc_hd__tapvpwrvgnd_1
XTAP_130 VGND VPWR sky130_fd_sc_hd__tapvpwrvgnd_1
XTAP_152 VGND VPWR sky130_fd_sc_hd__tapvpwrvgnd_1
XTAP_163 VGND VPWR sky130_fd_sc_hd__tapvpwrvgnd_1
XTAP_174 VGND VPWR sky130_fd_sc_hd__tapvpwrvgnd_1
XTAP_185 VGND VPWR sky130_fd_sc_hd__tapvpwrvgnd_1
XTAP_196 VGND VPWR sky130_fd_sc_hd__tapvpwrvgnd_1
XFILLER_0_23_15 VGND VGND VPWR VPWR sky130_fd_sc_hd__fill_2
X_0790_ _0162_ net110 _0376_ VGND VGND VPWR VPWR _0378_ sky130_fd_sc_hd__mux2_1
XFILLER_0_23_222 VGND VGND VPWR VPWR sky130_fd_sc_hd__fill_2
X_0988_ clknet_4_1_0_clk _0092_ VGND VGND VPWR VPWR memory\[10\]\[3\] sky130_fd_sc_hd__dfxtp_1
XFILLER_0_14_277 VGND VGND VPWR VPWR sky130_fd_sc_hd__fill_2
XFILLER_0_9_293 VPWR VGND VPWR VGND sky130_ef_sc_hd__decap_12
X_0911_ clknet_4_5_0_clk _0015_ VGND VGND VPWR VPWR memory\[2\]\[6\] sky130_fd_sc_hd__dfxtp_1
X_0842_ net26 _0156_ _0405_ VGND VGND VPWR VPWR _0138_ sky130_fd_sc_hd__o21a_1
X_0773_ net31 net4 _0367_ VGND VGND VPWR VPWR _0369_ sky130_fd_sc_hd__mux2_1
XFILLER_0_11_225 VGND VGND VPWR VPWR sky130_fd_sc_hd__decap_8
XFILLER_0_46_177 VPWR VGND VPWR VGND sky130_ef_sc_hd__decap_12
XFILLER_0_10_280 VPWR VGND VPWR VGND sky130_ef_sc_hd__decap_12
XFILLER_0_37_122 VGND VGND VPWR VPWR sky130_fd_sc_hd__decap_8
XFILLER_0_45_57 VGND VGND VPWR VPWR sky130_fd_sc_hd__decap_4
X_1041_ clknet_4_9_0_clk _0145_ VGND VGND VPWR VPWR read_pointer\[3\] sky130_fd_sc_hd__dfxtp_2
X_0825_ _0162_ net132 _0395_ VGND VGND VPWR VPWR _0397_ sky130_fd_sc_hd__mux2_1
XFILLER_0_9_57 VGND VGND VPWR VPWR sky130_fd_sc_hd__decap_8
XFILLER_0_28_166 VPWR VGND VPWR VGND sky130_ef_sc_hd__decap_12
X_0756_ net64 net4 _0358_ VGND VGND VPWR VPWR _0360_ sky130_fd_sc_hd__mux2_1
X_0687_ _0164_ net141 _0319_ VGND VGND VPWR VPWR _0322_ sky130_fd_sc_hd__mux2_1
XFILLER_0_10_93 VGND VGND VPWR VPWR sky130_fd_sc_hd__decap_8
XFILLER_0_19_100 VGND VGND VPWR VPWR sky130_fd_sc_hd__fill_2
XFILLER_0_19_111 VGND VGND VPWR VPWR sky130_fd_sc_hd__fill_1
XFILLER_0_19_155 VPWR VGND VPWR VGND sky130_ef_sc_hd__decap_12
XFILLER_0_34_136 VGND VGND VPWR VPWR sky130_fd_sc_hd__decap_4
XFILLER_0_40_117 VGND VGND VPWR VPWR sky130_fd_sc_hd__decap_4
XFILLER_0_25_169 VPWR VGND VPWR VGND sky130_ef_sc_hd__decap_12
XFILLER_0_31_15 VGND VGND VPWR VPWR sky130_fd_sc_hd__fill_1
XFILLER_0_0_225 VPWR VGND VPWR VGND sky130_ef_sc_hd__decap_12
X_0472_ _0169_ VGND VGND VPWR VPWR _0004_ sky130_fd_sc_hd__clkbuf_1
X_0610_ read_pointer\[3\] _0266_ VGND VGND VPWR VPWR _0267_ sky130_fd_sc_hd__and2b_1
X_0541_ write_pointer\[3\] write_pointer\[2\] VGND VGND VPWR VPWR _0210_ sky130_fd_sc_hd__or2_1
X_1024_ clknet_4_3_0_clk _0128_ VGND VGND VPWR VPWR memory\[8\]\[7\] sky130_fd_sc_hd__dfxtp_1
X_0808_ net58 net4 _0386_ VGND VGND VPWR VPWR _0388_ sky130_fd_sc_hd__mux2_1
X_0739_ _0350_ VGND VGND VPWR VPWR _0090_ sky130_fd_sc_hd__clkbuf_1
XFILLER_0_47_261 VPWR VGND VPWR VGND sky130_ef_sc_hd__decap_12
XFILLER_0_30_194 VGND VGND VPWR VPWR sky130_fd_sc_hd__fill_2
Xhold60 memory\[9\]\[0\] VGND VGND VPWR VPWR net85 sky130_fd_sc_hd__dlygate4sd3_1
Xhold71 memory\[12\]\[6\] VGND VGND VPWR VPWR net96 sky130_fd_sc_hd__dlygate4sd3_1
Xhold82 memory\[12\]\[3\] VGND VGND VPWR VPWR net107 sky130_fd_sc_hd__dlygate4sd3_1
XFILLER_0_26_15 VGND VGND VPWR VPWR sky130_fd_sc_hd__fill_2
XFILLER_0_26_26 VGND VGND VPWR VPWR sky130_fd_sc_hd__fill_2
XFILLER_0_26_48 VPWR VGND VPWR VGND sky130_ef_sc_hd__decap_12
Xhold93 memory\[6\]\[5\] VGND VGND VPWR VPWR net118 sky130_fd_sc_hd__dlygate4sd3_1
XFILLER_0_38_261 VPWR VGND VPWR VGND sky130_ef_sc_hd__decap_12
XFILLER_0_38_250 VGND VGND VPWR VPWR sky130_fd_sc_hd__fill_2
Xclkbuf_4_14_0_clk clknet_0_clk VGND VGND VPWR VPWR clknet_4_14_0_clk sky130_fd_sc_hd__clkbuf_8
XTAP_367 VGND VPWR sky130_fd_sc_hd__tapvpwrvgnd_1
XTAP_356 VGND VPWR sky130_fd_sc_hd__tapvpwrvgnd_1
XTAP_345 VGND VPWR sky130_fd_sc_hd__tapvpwrvgnd_1
XTAP_334 VGND VPWR sky130_fd_sc_hd__tapvpwrvgnd_1
XTAP_323 VGND VPWR sky130_fd_sc_hd__tapvpwrvgnd_1
XTAP_312 VGND VPWR sky130_fd_sc_hd__tapvpwrvgnd_1
XTAP_301 VGND VPWR sky130_fd_sc_hd__tapvpwrvgnd_1
X_0455_ write_pointer\[1\] write_pointer\[0\] _0156_ VGND VGND VPWR VPWR _0157_ sky130_fd_sc_hd__and3_2
X_0524_ _0200_ VGND VGND VPWR VPWR _0201_ sky130_fd_sc_hd__clkbuf_4
X_1007_ clknet_4_7_0_clk _0111_ VGND VGND VPWR VPWR memory\[0\]\[6\] sky130_fd_sc_hd__dfxtp_1
XPHY_18 VGND VGND VPWR VPWR sky130_fd_sc_hd__decap_3
XPHY_29 VGND VGND VPWR VPWR sky130_fd_sc_hd__decap_3
XFILLER_0_44_253 VPWR VGND VPWR VGND sky130_ef_sc_hd__decap_12
XFILLER_0_35_220 VGND VGND VPWR VPWR sky130_fd_sc_hd__decap_4
XFILLER_0_50_289 VPWR VGND VPWR VGND sky130_ef_sc_hd__decap_12
XFILLER_0_18_209 VGND VGND VPWR VPWR sky130_fd_sc_hd__decap_8
XFILLER_0_26_253 VGND VGND VPWR VPWR sky130_fd_sc_hd__fill_2
XFILLER_0_41_256 VPWR VGND VPWR VGND sky130_ef_sc_hd__decap_12
XFILLER_0_41_212 VPWR VGND VPWR VGND sky130_ef_sc_hd__decap_12
XFILLER_0_5_169 VGND VGND VPWR VPWR sky130_fd_sc_hd__fill_1
XTAP_142 VGND VPWR sky130_fd_sc_hd__tapvpwrvgnd_1
XTAP_131 VGND VPWR sky130_fd_sc_hd__tapvpwrvgnd_1
X_0507_ _0191_ VGND VGND VPWR VPWR _0017_ sky130_fd_sc_hd__clkbuf_1
XTAP_120 VGND VPWR sky130_fd_sc_hd__tapvpwrvgnd_1
XTAP_153 VGND VPWR sky130_fd_sc_hd__tapvpwrvgnd_1
XTAP_164 VGND VPWR sky130_fd_sc_hd__tapvpwrvgnd_1
XTAP_175 VGND VPWR sky130_fd_sc_hd__tapvpwrvgnd_1
XTAP_186 VGND VPWR sky130_fd_sc_hd__tapvpwrvgnd_1
XTAP_197 VGND VPWR sky130_fd_sc_hd__tapvpwrvgnd_1
XFILLER_0_2_117 VGND VGND VPWR VPWR sky130_fd_sc_hd__decap_6
XFILLER_0_23_267 VGND VGND VPWR VPWR sky130_fd_sc_hd__decap_4
XFILLER_0_3_15 VPWR VGND VPWR VGND sky130_ef_sc_hd__decap_12
X_0987_ clknet_4_10_0_clk _0091_ VGND VGND VPWR VPWR memory\[10\]\[2\] sky130_fd_sc_hd__dfxtp_1
XFILLER_0_14_223 VGND VGND VPWR VPWR sky130_fd_sc_hd__decap_4
XFILLER_0_34_15 VPWR VGND VPWR VGND sky130_ef_sc_hd__decap_12
X_0772_ _0368_ VGND VGND VPWR VPWR _0105_ sky130_fd_sc_hd__clkbuf_1
X_0841_ _0296_ _0188_ VGND VGND VPWR VPWR _0405_ sky130_fd_sc_hd__nor2_1
X_0910_ clknet_4_4_0_clk _0014_ VGND VGND VPWR VPWR memory\[2\]\[5\] sky130_fd_sc_hd__dfxtp_1
XFILLER_0_19_304 VGND VGND VPWR VPWR sky130_fd_sc_hd__decap_3
XFILLER_0_46_189 VGND VGND VPWR VPWR sky130_fd_sc_hd__decap_6
XFILLER_0_6_253 VPWR VGND VPWR VGND sky130_ef_sc_hd__decap_12
XFILLER_0_10_292 VPWR VGND VPWR VGND sky130_ef_sc_hd__decap_12
X_1040_ clknet_4_9_0_clk _0144_ VGND VGND VPWR VPWR read_pointer\[2\] sky130_fd_sc_hd__dfxtp_4
XFILLER_0_0_27 VGND VGND VPWR VPWR sky130_fd_sc_hd__fill_1
XFILLER_0_0_49 VGND VGND VPWR VPWR sky130_fd_sc_hd__decap_6
XFILLER_0_51_181 VPWR VGND VPWR VGND sky130_ef_sc_hd__decap_12
XFILLER_0_3_223 VGND VGND VPWR VPWR sky130_fd_sc_hd__fill_1
XFILLER_0_10_61 VPWR VGND VPWR VGND sky130_ef_sc_hd__decap_12
XFILLER_0_28_178 VPWR VGND VPWR VGND sky130_ef_sc_hd__decap_12
X_0755_ _0359_ VGND VGND VPWR VPWR _0097_ sky130_fd_sc_hd__clkbuf_1
X_0824_ _0396_ VGND VGND VPWR VPWR _0129_ sky130_fd_sc_hd__clkbuf_1
X_0686_ _0321_ VGND VGND VPWR VPWR _0066_ sky130_fd_sc_hd__clkbuf_1
XFILLER_0_29_3 VGND VGND VPWR VPWR sky130_fd_sc_hd__decap_8
XFILLER_0_19_167 VGND VGND VPWR VPWR sky130_fd_sc_hd__fill_1
X_0540_ _0209_ VGND VGND VPWR VPWR _0032_ sky130_fd_sc_hd__clkbuf_1
XFILLER_0_0_237 VPWR VGND VPWR VGND sky130_ef_sc_hd__decap_12
X_0471_ net48 _0168_ _0160_ VGND VGND VPWR VPWR _0169_ sky130_fd_sc_hd__mux2_1
X_1023_ clknet_4_2_0_clk _0127_ VGND VGND VPWR VPWR memory\[8\]\[6\] sky130_fd_sc_hd__dfxtp_1
X_0807_ _0387_ VGND VGND VPWR VPWR _0121_ sky130_fd_sc_hd__clkbuf_1
X_0738_ _0162_ net122 _0348_ VGND VGND VPWR VPWR _0350_ sky130_fd_sc_hd__mux2_1
XFILLER_0_31_107 VGND VGND VPWR VPWR sky130_fd_sc_hd__decap_4
X_0669_ _0312_ VGND VGND VPWR VPWR _0058_ sky130_fd_sc_hd__clkbuf_1
XFILLER_0_1_81 VPWR VGND VPWR VGND sky130_ef_sc_hd__decap_12
XFILLER_0_47_273 VGND VGND VPWR VPWR sky130_fd_sc_hd__decap_6
Xhold83 memory\[15\]\[5\] VGND VGND VPWR VPWR net108 sky130_fd_sc_hd__dlygate4sd3_1
Xhold72 memory\[12\]\[0\] VGND VGND VPWR VPWR net97 sky130_fd_sc_hd__dlygate4sd3_1
Xhold50 memory\[11\]\[5\] VGND VGND VPWR VPWR net75 sky130_fd_sc_hd__dlygate4sd3_1
Xhold94 memory\[15\]\[3\] VGND VGND VPWR VPWR net119 sky130_fd_sc_hd__dlygate4sd3_1
Xhold61 memory\[9\]\[3\] VGND VGND VPWR VPWR net86 sky130_fd_sc_hd__dlygate4sd3_1
XFILLER_0_38_273 VPWR VGND VPWR VGND sky130_ef_sc_hd__decap_12
XFILLER_0_6_48 VGND VGND VPWR VPWR sky130_fd_sc_hd__fill_2
XTAP_368 VGND VPWR sky130_fd_sc_hd__tapvpwrvgnd_1
XTAP_357 VGND VPWR sky130_fd_sc_hd__tapvpwrvgnd_1
XTAP_346 VGND VPWR sky130_fd_sc_hd__tapvpwrvgnd_1
XTAP_335 VGND VPWR sky130_fd_sc_hd__tapvpwrvgnd_1
XTAP_324 VGND VPWR sky130_fd_sc_hd__tapvpwrvgnd_1
XTAP_313 VGND VPWR sky130_fd_sc_hd__tapvpwrvgnd_1
XTAP_302 VGND VPWR sky130_fd_sc_hd__tapvpwrvgnd_1
X_0454_ data_count\[4\] net24 net11 VGND VGND VPWR VPWR _0156_ sky130_fd_sc_hd__a21boi_4
X_0523_ _0155_ _0157_ _0199_ VGND VGND VPWR VPWR _0200_ sky130_fd_sc_hd__and3_1
XPHY_19 VGND VGND VPWR VPWR sky130_fd_sc_hd__decap_3
XFILLER_0_16_82 VGND VGND VPWR VPWR sky130_fd_sc_hd__fill_2
XFILLER_0_16_93 VGND VGND VPWR VPWR sky130_fd_sc_hd__decap_4
X_1006_ clknet_4_6_0_clk _0110_ VGND VGND VPWR VPWR memory\[0\]\[5\] sky130_fd_sc_hd__dfxtp_1
XFILLER_0_44_265 VPWR VGND VPWR VGND sky130_ef_sc_hd__decap_12
XFILLER_0_8_145 VGND VGND VPWR VPWR sky130_fd_sc_hd__fill_1
XFILLER_0_41_268 VPWR VGND VPWR VGND sky130_ef_sc_hd__decap_12
XTAP_132 VGND VPWR sky130_fd_sc_hd__tapvpwrvgnd_1
X_0506_ _0154_ net68 _0190_ VGND VGND VPWR VPWR _0191_ sky130_fd_sc_hd__mux2_1
XTAP_121 VGND VPWR sky130_fd_sc_hd__tapvpwrvgnd_1
XTAP_110 VGND VPWR sky130_fd_sc_hd__tapvpwrvgnd_1
XTAP_143 VGND VPWR sky130_fd_sc_hd__tapvpwrvgnd_1
XTAP_154 VGND VPWR sky130_fd_sc_hd__tapvpwrvgnd_1
XTAP_165 VGND VPWR sky130_fd_sc_hd__tapvpwrvgnd_1
XTAP_176 VGND VPWR sky130_fd_sc_hd__tapvpwrvgnd_1
XTAP_187 VGND VPWR sky130_fd_sc_hd__tapvpwrvgnd_1
XTAP_198 VGND VPWR sky130_fd_sc_hd__tapvpwrvgnd_1
XFILLER_0_27_81 VPWR VGND VPWR VGND sky130_ef_sc_hd__decap_12
XFILLER_0_11_3 VGND VGND VPWR VPWR sky130_fd_sc_hd__decap_4
XFILLER_0_4_192 VGND VGND VPWR VPWR sky130_fd_sc_hd__decap_4
Xclkbuf_4_13_0_clk clknet_0_clk VGND VGND VPWR VPWR clknet_4_13_0_clk sky130_fd_sc_hd__clkbuf_8
XFILLER_0_3_27 VGND VGND VPWR VPWR sky130_fd_sc_hd__decap_8
X_0986_ clknet_4_8_0_clk _0090_ VGND VGND VPWR VPWR memory\[10\]\[1\] sky130_fd_sc_hd__dfxtp_1
XFILLER_0_14_213 VGND VGND VPWR VPWR sky130_fd_sc_hd__fill_1
XFILLER_0_37_305 VGND VGND VPWR VPWR sky130_fd_sc_hd__fill_2
XFILLER_0_50_15 VPWR VGND VPWR VGND sky130_ef_sc_hd__decap_12
XFILLER_0_34_27 VGND VGND VPWR VPWR sky130_fd_sc_hd__fill_1
X_0840_ _0404_ VGND VGND VPWR VPWR _0137_ sky130_fd_sc_hd__clkbuf_1
X_0771_ net47 net3 _0367_ VGND VGND VPWR VPWR _0368_ sky130_fd_sc_hd__mux2_1
XFILLER_0_6_265 VPWR VGND VPWR VGND sky130_ef_sc_hd__decap_12
X_0969_ clknet_4_2_0_clk _0073_ VGND VGND VPWR VPWR memory\[11\]\[0\] sky130_fd_sc_hd__dfxtp_1
XFILLER_0_4_70 VPWR VGND VPWR VGND sky130_ef_sc_hd__decap_12
XFILLER_0_45_15 VPWR VGND VPWR VGND sky130_ef_sc_hd__decap_12
XFILLER_0_9_15 VPWR VGND VPWR VGND sky130_ef_sc_hd__decap_12
XFILLER_0_51_193 VGND VGND VPWR VPWR sky130_fd_sc_hd__decap_3
XFILLER_0_43_138 VPWR VGND VPWR VGND sky130_ef_sc_hd__decap_12
X_0685_ _0162_ net149 _0319_ VGND VGND VPWR VPWR _0321_ sky130_fd_sc_hd__mux2_1
XFILLER_0_3_279 VGND VGND VPWR VPWR sky130_fd_sc_hd__fill_1
XFILLER_0_10_73 VGND VGND VPWR VPWR sky130_fd_sc_hd__decap_3
X_0754_ net38 net3 _0358_ VGND VGND VPWR VPWR _0359_ sky130_fd_sc_hd__mux2_1
X_0823_ _0154_ net92 _0395_ VGND VGND VPWR VPWR _0396_ sky130_fd_sc_hd__mux2_1
XFILLER_0_35_81 VPWR VGND VPWR VGND sky130_ef_sc_hd__decap_12
XFILLER_0_31_39 VGND VGND VPWR VPWR sky130_fd_sc_hd__decap_4
XFILLER_0_25_149 VGND VGND VPWR VPWR sky130_fd_sc_hd__fill_1
X_0470_ net7 VGND VGND VPWR VPWR _0168_ sky130_fd_sc_hd__buf_2
XFILLER_0_0_249 VGND VGND VPWR VPWR sky130_fd_sc_hd__decap_3
X_1022_ clknet_4_2_0_clk _0126_ VGND VGND VPWR VPWR memory\[8\]\[5\] sky130_fd_sc_hd__dfxtp_1
X_0668_ net93 net4 _0310_ VGND VGND VPWR VPWR _0312_ sky130_fd_sc_hd__mux2_1
X_0806_ net82 net3 _0386_ VGND VGND VPWR VPWR _0387_ sky130_fd_sc_hd__mux2_1
X_0737_ _0349_ VGND VGND VPWR VPWR _0089_ sky130_fd_sc_hd__clkbuf_1
X_0599_ memory\[4\]\[3\] memory\[5\]\[3\] memory\[6\]\[3\] memory\[7\]\[3\] read_pointer\[0\]
+ _0237_ VGND VGND VPWR VPWR _0257_ sky130_fd_sc_hd__mux4_1
XFILLER_0_41_3 VPWR VGND VPWR VGND sky130_ef_sc_hd__decap_12
XFILLER_0_1_93 VGND VGND VPWR VPWR sky130_fd_sc_hd__decap_8
Xhold40 memory\[12\]\[4\] VGND VGND VPWR VPWR net65 sky130_fd_sc_hd__dlygate4sd3_1
XFILLER_0_30_174 VGND VGND VPWR VPWR sky130_fd_sc_hd__fill_1
Xhold51 memory\[2\]\[1\] VGND VGND VPWR VPWR net76 sky130_fd_sc_hd__dlygate4sd3_1
Xhold73 memory\[1\]\[0\] VGND VGND VPWR VPWR net98 sky130_fd_sc_hd__dlygate4sd3_1
Xhold84 memory\[8\]\[6\] VGND VGND VPWR VPWR net109 sky130_fd_sc_hd__dlygate4sd3_1
Xhold62 memory\[13\]\[4\] VGND VGND VPWR VPWR net87 sky130_fd_sc_hd__dlygate4sd3_1
Xhold95 memory\[14\]\[3\] VGND VGND VPWR VPWR net120 sky130_fd_sc_hd__dlygate4sd3_1
XFILLER_0_38_285 VPWR VGND VPWR VGND sky130_ef_sc_hd__decap_12
XTAP_314 VGND VPWR sky130_fd_sc_hd__tapvpwrvgnd_1
XTAP_303 VGND VPWR sky130_fd_sc_hd__tapvpwrvgnd_1
XFILLER_0_6_38 VGND VGND VPWR VPWR sky130_fd_sc_hd__fill_1
XFILLER_0_21_152 VGND VGND VPWR VPWR sky130_fd_sc_hd__decap_3
XFILLER_0_21_163 VGND VGND VPWR VPWR sky130_fd_sc_hd__decap_4
X_0522_ write_pointer\[3\] write_pointer\[2\] VGND VGND VPWR VPWR _0199_ sky130_fd_sc_hd__and2b_2
XTAP_369 VGND VPWR sky130_fd_sc_hd__tapvpwrvgnd_1
XTAP_358 VGND VPWR sky130_fd_sc_hd__tapvpwrvgnd_1
XTAP_347 VGND VPWR sky130_fd_sc_hd__tapvpwrvgnd_1
XTAP_336 VGND VPWR sky130_fd_sc_hd__tapvpwrvgnd_1
XTAP_325 VGND VPWR sky130_fd_sc_hd__tapvpwrvgnd_1
X_0453_ net2 VGND VGND VPWR VPWR _0155_ sky130_fd_sc_hd__buf_2
X_1005_ clknet_4_15_0_clk _0109_ VGND VGND VPWR VPWR memory\[0\]\[4\] sky130_fd_sc_hd__dfxtp_1
XFILLER_0_44_277 VPWR VGND VPWR VGND sky130_ef_sc_hd__decap_12
XFILLER_0_12_141 VPWR VGND VPWR VGND sky130_ef_sc_hd__decap_12
XFILLER_0_26_211 VGND VGND VPWR VPWR sky130_fd_sc_hd__decap_3
XTAP_144 VGND VPWR sky130_fd_sc_hd__tapvpwrvgnd_1
XTAP_133 VGND VPWR sky130_fd_sc_hd__tapvpwrvgnd_1
XTAP_122 VGND VPWR sky130_fd_sc_hd__tapvpwrvgnd_1
XTAP_111 VGND VPWR sky130_fd_sc_hd__tapvpwrvgnd_1
XTAP_155 VGND VPWR sky130_fd_sc_hd__tapvpwrvgnd_1
XTAP_166 VGND VPWR sky130_fd_sc_hd__tapvpwrvgnd_1
X_0505_ _0158_ _0189_ VGND VGND VPWR VPWR _0190_ sky130_fd_sc_hd__nand2_4
.ends
